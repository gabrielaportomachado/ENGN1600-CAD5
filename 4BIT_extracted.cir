* Extracted by KLayout with GF180MCU LVS runset on : 05/04/2026 00:04

.SUBCKT 4BIT Ax\x2d3 Ax\x2d2 Ax\x2d1 Ax GND OUT3 Sh IN3 Shb IN2 OUT2 OUT1 IN1
+ OUT0 IN0
M$1 OUT3 Sh Ax\x2d3 GND nfet_03v3 L=0.28U W=0.5U AS=0.3575P AD=0.18625P
+ PS=2.43U PD=1.245U
M$2 IN3 Shb OUT3 GND nfet_03v3 L=0.28U W=0.5U AS=0.18625P AD=0.27P PS=1.245U
+ PD=2.08U
M$3 OUT2 Sh Ax\x2d2 GND nfet_03v3 L=0.28U W=0.5U AS=0.3775P AD=0.18625P
+ PS=2.51U PD=1.245U
M$4 IN2 Shb OUT2 GND nfet_03v3 L=0.28U W=0.5U AS=0.18625P AD=0.2625P PS=1.245U
+ PD=2.05U
M$5 OUT1 Sh Ax\x2d1 GND nfet_03v3 L=0.28U W=0.5U AS=0.3575P AD=0.18625P
+ PS=2.43U PD=1.245U
M$6 IN1 Shb OUT1 GND nfet_03v3 L=0.28U W=0.5U AS=0.18625P AD=0.27P PS=1.245U
+ PD=2.08U
M$7 OUT0 Sh Ax GND nfet_03v3 L=0.28U W=0.5U AS=0.3775P AD=0.18625P PS=2.51U
+ PD=1.245U
M$8 IN0 Shb OUT0 GND nfet_03v3 L=0.28U W=0.5U AS=0.18625P AD=0.2625P PS=1.245U
+ PD=2.05U
.ENDS 4BIT
