* Extracted by KLayout with GF180MCU LVS runset on : 09/04/2026 03:57

.SUBCKT SHIFT A15 GND Sh1 Sh2 Sh4 Sh8 Sh1b A14 Sh2b Sh4b Sh8b OUT15 A13 OUT14
+ A12 OUT13 OUT12 A11 OUT11 A10 A9 OUT10 A8 OUT9 OUT8 A7 OUT7 A6 OUT6 A5 A4
+ OUT5 OUT4 A3 OUT3 A2 OUT2 VDD A1 A0 OUT1 OUT0
M$1 \$127 \$131 VDD VDD pfet_03v3 L=0.28U W=1U AS=0.65P AD=0.595P PS=3.3U
+ PD=3.19U
M$2 OUT3 \$127 VDD VDD pfet_03v3 L=0.28U W=1U AS=0.595P AD=0.65P PS=3.19U
+ PD=3.3U
M$3 \$136 \$145 VDD VDD pfet_03v3 L=0.28U W=1U AS=0.65P AD=0.595P PS=3.3U
+ PD=3.19U
M$4 OUT2 \$136 VDD VDD pfet_03v3 L=0.28U W=1U AS=0.595P AD=0.65P PS=3.19U
+ PD=3.3U
M$5 \$159 \$158 VDD VDD pfet_03v3 L=0.28U W=1U AS=0.65P AD=0.595P PS=3.3U
+ PD=3.19U
M$6 OUT1 \$159 VDD VDD pfet_03v3 L=0.28U W=1U AS=0.595P AD=0.65P PS=3.19U
+ PD=3.3U
M$7 \$171 \$170 VDD VDD pfet_03v3 L=0.28U W=1U AS=0.65P AD=0.595P PS=3.3U
+ PD=3.19U
M$8 OUT0 \$171 VDD VDD pfet_03v3 L=0.28U W=1U AS=0.595P AD=0.65P PS=3.19U
+ PD=3.3U
M$9 \$3 Sh1 A15 GND nfet_03v3 L=0.28U W=0.5U AS=0.3775P AD=0.18625P PS=2.51U
+ PD=1.245U
M$10 A14 Sh1b \$3 GND nfet_03v3 L=0.28U W=0.5U AS=0.18625P AD=0.2625P PS=1.245U
+ PD=2.05U
M$11 \$6 Sh2 \$3 GND nfet_03v3 L=0.28U W=0.5U AS=0.355P AD=0.18625P PS=2.42U
+ PD=1.245U
M$12 \$16 Sh2b \$6 GND nfet_03v3 L=0.28U W=0.5U AS=0.18625P AD=0.2625P
+ PS=1.245U PD=2.05U
M$13 \$9 Sh4 \$6 GND nfet_03v3 L=0.28U W=0.5U AS=0.3575P AD=0.18625P PS=2.43U
+ PD=1.245U
M$14 \$18 Sh4b \$9 GND nfet_03v3 L=0.28U W=0.5U AS=0.18625P AD=0.27P PS=1.245U
+ PD=2.08U
M$15 OUT15 Sh8 \$9 GND nfet_03v3 L=0.28U W=0.5U AS=0.3575P AD=0.18625P PS=2.43U
+ PD=1.245U
M$16 \$93 Sh8b OUT15 GND nfet_03v3 L=0.28U W=0.5U AS=0.18625P AD=0.27P
+ PS=1.245U PD=2.08U
M$17 \$4 Sh1 A14 GND nfet_03v3 L=0.28U W=0.5U AS=0.3775P AD=0.18625P PS=2.51U
+ PD=1.245U
M$18 A13 Sh1b \$4 GND nfet_03v3 L=0.28U W=0.5U AS=0.18625P AD=0.2625P PS=1.245U
+ PD=2.05U
M$19 \$27 Sh2 \$4 GND nfet_03v3 L=0.28U W=0.5U AS=0.3775P AD=0.18625P PS=2.51U
+ PD=1.245U
M$20 \$28 Sh2b \$27 GND nfet_03v3 L=0.28U W=0.5U AS=0.18625P AD=0.2625P
+ PS=1.245U PD=2.05U
M$21 \$29 Sh4 \$27 GND nfet_03v3 L=0.28U W=0.5U AS=0.3775P AD=0.18625P PS=2.51U
+ PD=1.245U
M$22 \$31 Sh4b \$29 GND nfet_03v3 L=0.28U W=0.5U AS=0.18625P AD=0.2625P
+ PS=1.245U PD=2.05U
M$23 OUT14 Sh8 \$29 GND nfet_03v3 L=0.28U W=0.5U AS=0.3775P AD=0.18625P
+ PS=2.51U PD=1.245U
M$24 \$32 Sh8b OUT14 GND nfet_03v3 L=0.28U W=0.5U AS=0.18625P AD=0.2625P
+ PS=1.245U PD=2.05U
M$25 \$16 Sh1 A13 GND nfet_03v3 L=0.28U W=0.5U AS=0.3775P AD=0.18625P PS=2.51U
+ PD=1.245U
M$26 A12 Sh1b \$16 GND nfet_03v3 L=0.28U W=0.5U AS=0.18625P AD=0.2625P
+ PS=1.245U PD=2.05U
M$27 \$37 Sh2 \$16 GND nfet_03v3 L=0.28U W=0.5U AS=0.355P AD=0.18625P PS=2.42U
+ PD=1.245U
M$28 \$39 Sh2b \$37 GND nfet_03v3 L=0.28U W=0.5U AS=0.18625P AD=0.2625P
+ PS=1.245U PD=2.05U
M$29 \$10 Sh4 \$37 GND nfet_03v3 L=0.28U W=0.5U AS=0.3575P AD=0.18625P PS=2.43U
+ PD=1.245U
M$30 \$40 Sh4b \$10 GND nfet_03v3 L=0.28U W=0.5U AS=0.18625P AD=0.27P PS=1.245U
+ PD=2.08U
M$31 OUT13 Sh8 \$10 GND nfet_03v3 L=0.28U W=0.5U AS=0.3575P AD=0.18625P
+ PS=2.43U PD=1.245U
M$32 \$41 Sh8b OUT13 GND nfet_03v3 L=0.28U W=0.5U AS=0.18625P AD=0.27P
+ PS=1.245U PD=2.08U
M$33 \$28 Sh1 A12 GND nfet_03v3 L=0.28U W=0.5U AS=0.3775P AD=0.18625P PS=2.51U
+ PD=1.245U
M$34 A11 Sh1b \$28 GND nfet_03v3 L=0.28U W=0.5U AS=0.18625P AD=0.2625P
+ PS=1.245U PD=2.05U
M$35 \$47 Sh2 \$28 GND nfet_03v3 L=0.28U W=0.5U AS=0.3775P AD=0.18625P PS=2.51U
+ PD=1.245U
M$36 \$51 Sh2b \$47 GND nfet_03v3 L=0.28U W=0.5U AS=0.18625P AD=0.2625P
+ PS=1.245U PD=2.05U
M$37 \$48 Sh4 \$47 GND nfet_03v3 L=0.28U W=0.5U AS=0.3775P AD=0.18625P PS=2.51U
+ PD=1.245U
M$38 \$84 Sh4b \$48 GND nfet_03v3 L=0.28U W=0.5U AS=0.18625P AD=0.2625P
+ PS=1.245U PD=2.05U
M$39 OUT12 Sh8 \$48 GND nfet_03v3 L=0.28U W=0.5U AS=0.3775P AD=0.18625P
+ PS=2.51U PD=1.245U
M$40 \$118 Sh8b OUT12 GND nfet_03v3 L=0.28U W=0.5U AS=0.18625P AD=0.2625P
+ PS=1.245U PD=2.05U
M$41 \$39 Sh1 A11 GND nfet_03v3 L=0.28U W=0.5U AS=0.3775P AD=0.18625P PS=2.51U
+ PD=1.245U
M$42 A10 Sh1b \$39 GND nfet_03v3 L=0.28U W=0.5U AS=0.18625P AD=0.2625P
+ PS=1.245U PD=2.05U
M$43 \$18 Sh2 \$39 GND nfet_03v3 L=0.28U W=0.5U AS=0.355P AD=0.18625P PS=2.42U
+ PD=1.245U
M$44 \$56 Sh2b \$18 GND nfet_03v3 L=0.28U W=0.5U AS=0.18625P AD=0.2625P
+ PS=1.245U PD=2.05U
M$45 \$11 Sh4 \$18 GND nfet_03v3 L=0.28U W=0.5U AS=0.3575P AD=0.18625P PS=2.43U
+ PD=1.245U
M$46 \$59 Sh4b \$11 GND nfet_03v3 L=0.28U W=0.5U AS=0.18625P AD=0.27P PS=1.245U
+ PD=2.08U
M$47 OUT11 Sh8 \$11 GND nfet_03v3 L=0.28U W=0.5U AS=0.3575P AD=0.18625P
+ PS=2.43U PD=1.245U
M$48 \$60 Sh8b OUT11 GND nfet_03v3 L=0.28U W=0.5U AS=0.18625P AD=0.27P
+ PS=1.245U PD=2.08U
M$49 \$51 Sh1 A10 GND nfet_03v3 L=0.28U W=0.5U AS=0.3775P AD=0.18625P PS=2.51U
+ PD=1.245U
M$50 A9 Sh1b \$51 GND nfet_03v3 L=0.28U W=0.5U AS=0.18625P AD=0.2625P PS=1.245U
+ PD=2.05U
M$51 \$31 Sh2 \$51 GND nfet_03v3 L=0.28U W=0.5U AS=0.3775P AD=0.18625P PS=2.51U
+ PD=1.245U
M$52 \$83 Sh2b \$31 GND nfet_03v3 L=0.28U W=0.5U AS=0.18625P AD=0.2625P
+ PS=1.245U PD=2.05U
M$53 \$12 Sh4 \$31 GND nfet_03v3 L=0.28U W=0.5U AS=0.3775P AD=0.18625P PS=2.51U
+ PD=1.245U
M$54 \$66 Sh4b \$12 GND nfet_03v3 L=0.28U W=0.5U AS=0.18625P AD=0.2625P
+ PS=1.245U PD=2.05U
M$55 OUT10 Sh8 \$12 GND nfet_03v3 L=0.28U W=0.5U AS=0.3775P AD=0.18625P
+ PS=2.51U PD=1.245U
M$56 \$67 Sh8b OUT10 GND nfet_03v3 L=0.28U W=0.5U AS=0.18625P AD=0.2625P
+ PS=1.245U PD=2.05U
M$57 \$56 Sh1 A9 GND nfet_03v3 L=0.28U W=0.5U AS=0.3775P AD=0.18625P PS=2.51U
+ PD=1.245U
M$58 A8 Sh1b \$56 GND nfet_03v3 L=0.28U W=0.5U AS=0.18625P AD=0.2625P PS=1.245U
+ PD=2.05U
M$59 \$40 Sh2 \$56 GND nfet_03v3 L=0.28U W=0.5U AS=0.355P AD=0.18625P PS=2.42U
+ PD=1.245U
M$60 \$74 Sh2b \$40 GND nfet_03v3 L=0.28U W=0.5U AS=0.18625P AD=0.2625P
+ PS=1.245U PD=2.05U
M$61 \$75 Sh4 \$40 GND nfet_03v3 L=0.28U W=0.5U AS=0.3575P AD=0.18625P PS=2.43U
+ PD=1.245U
M$62 \$77 Sh4b \$75 GND nfet_03v3 L=0.28U W=0.5U AS=0.18625P AD=0.27P PS=1.245U
+ PD=2.08U
M$63 OUT9 Sh8 \$75 GND nfet_03v3 L=0.28U W=0.5U AS=0.3575P AD=0.18625P PS=2.43U
+ PD=1.245U
M$64 \$78 Sh8b OUT9 GND nfet_03v3 L=0.28U W=0.5U AS=0.18625P AD=0.27P PS=1.245U
+ PD=2.08U
M$65 \$83 Sh1 A8 GND nfet_03v3 L=0.28U W=0.5U AS=0.3775P AD=0.18625P PS=2.51U
+ PD=1.245U
M$66 A7 Sh1b \$83 GND nfet_03v3 L=0.28U W=0.5U AS=0.18625P AD=0.2625P PS=1.245U
+ PD=2.05U
M$67 \$84 Sh2 \$83 GND nfet_03v3 L=0.28U W=0.5U AS=0.3775P AD=0.18625P PS=2.51U
+ PD=1.245U
M$68 \$88 Sh2b \$84 GND nfet_03v3 L=0.28U W=0.5U AS=0.18625P AD=0.2625P
+ PS=1.245U PD=2.05U
M$69 \$85 Sh4 \$84 GND nfet_03v3 L=0.28U W=0.5U AS=0.3775P AD=0.18625P PS=2.51U
+ PD=1.245U
M$70 \$117 Sh4b \$85 GND nfet_03v3 L=0.28U W=0.5U AS=0.18625P AD=0.2625P
+ PS=1.245U PD=2.05U
M$71 OUT8 Sh8 \$85 GND nfet_03v3 L=0.28U W=0.5U AS=0.3775P AD=0.18625P PS=2.51U
+ PD=1.245U
M$72 \$94 Sh8b OUT8 GND nfet_03v3 L=0.28U W=0.5U AS=0.18625P AD=0.2625P
+ PS=1.245U PD=2.05U
M$73 \$74 Sh1 A7 GND nfet_03v3 L=0.28U W=0.5U AS=0.3775P AD=0.18625P PS=2.51U
+ PD=1.245U
M$74 A6 Sh1b \$74 GND nfet_03v3 L=0.28U W=0.5U AS=0.18625P AD=0.2625P PS=1.245U
+ PD=2.05U
M$75 \$59 Sh2 \$74 GND nfet_03v3 L=0.28U W=0.5U AS=0.355P AD=0.18625P PS=2.42U
+ PD=1.245U
M$76 \$97 Sh2b \$59 GND nfet_03v3 L=0.28U W=0.5U AS=0.18625P AD=0.2625P
+ PS=1.245U PD=2.05U
M$77 \$93 Sh4 \$59 GND nfet_03v3 L=0.28U W=0.5U AS=0.3575P AD=0.18625P PS=2.43U
+ PD=1.245U
M$78 \$129 Sh4b \$93 GND nfet_03v3 L=0.28U W=0.5U AS=0.18625P AD=0.27P
+ PS=1.245U PD=2.08U
M$79 OUT7 Sh8 \$93 GND nfet_03v3 L=0.28U W=0.5U AS=0.3575P AD=0.18625P PS=2.43U
+ PD=1.245U
M$80 GND Sh8b OUT7 GND nfet_03v3 L=0.28U W=0.5U AS=0.18625P AD=0.27P PS=1.245U
+ PD=2.08U
M$81 \$88 Sh1 A6 GND nfet_03v3 L=0.28U W=0.5U AS=0.3775P AD=0.18625P PS=2.51U
+ PD=1.245U
M$82 A5 Sh1b \$88 GND nfet_03v3 L=0.28U W=0.5U AS=0.18625P AD=0.2625P PS=1.245U
+ PD=2.05U
M$83 \$66 Sh2 \$88 GND nfet_03v3 L=0.28U W=0.5U AS=0.3775P AD=0.18625P PS=2.51U
+ PD=1.245U
M$84 \$116 Sh2b \$66 GND nfet_03v3 L=0.28U W=0.5U AS=0.18625P AD=0.2625P
+ PS=1.245U PD=2.05U
M$85 \$32 Sh4 \$66 GND nfet_03v3 L=0.28U W=0.5U AS=0.3775P AD=0.18625P PS=2.51U
+ PD=1.245U
M$86 \$144 Sh4b \$32 GND nfet_03v3 L=0.28U W=0.5U AS=0.18625P AD=0.2625P
+ PS=1.245U PD=2.05U
M$87 OUT6 Sh8 \$32 GND nfet_03v3 L=0.28U W=0.5U AS=0.3775P AD=0.18625P PS=2.51U
+ PD=1.245U
M$88 GND Sh8b OUT6 GND nfet_03v3 L=0.28U W=0.5U AS=0.18625P AD=0.2625P
+ PS=1.245U PD=2.05U
M$89 \$97 Sh1 A5 GND nfet_03v3 L=0.28U W=0.5U AS=0.3775P AD=0.18625P PS=2.51U
+ PD=1.245U
M$90 A4 Sh1b \$97 GND nfet_03v3 L=0.28U W=0.5U AS=0.18625P AD=0.2625P PS=1.245U
+ PD=2.05U
M$91 \$77 Sh2 \$97 GND nfet_03v3 L=0.28U W=0.5U AS=0.355P AD=0.18625P PS=2.42U
+ PD=1.245U
M$92 \$109 Sh2b \$77 GND nfet_03v3 L=0.28U W=0.5U AS=0.18625P AD=0.2625P
+ PS=1.245U PD=2.05U
M$93 \$41 Sh4 \$77 GND nfet_03v3 L=0.28U W=0.5U AS=0.3575P AD=0.18625P PS=2.43U
+ PD=1.245U
M$94 \$110 Sh4b \$41 GND nfet_03v3 L=0.28U W=0.5U AS=0.18625P AD=0.27P
+ PS=1.245U PD=2.08U
M$95 OUT5 Sh8 \$41 GND nfet_03v3 L=0.28U W=0.5U AS=0.3575P AD=0.18625P PS=2.43U
+ PD=1.245U
M$96 GND Sh8b OUT5 GND nfet_03v3 L=0.28U W=0.5U AS=0.18625P AD=0.27P PS=1.245U
+ PD=2.08U
M$97 \$116 Sh1 A4 GND nfet_03v3 L=0.28U W=0.5U AS=0.3775P AD=0.18625P PS=2.51U
+ PD=1.245U
M$98 A3 Sh1b \$116 GND nfet_03v3 L=0.28U W=0.5U AS=0.18625P AD=0.2625P
+ PS=1.245U PD=2.05U
M$99 \$117 Sh2 \$116 GND nfet_03v3 L=0.28U W=0.5U AS=0.3775P AD=0.18625P
+ PS=2.51U PD=1.245U
M$100 \$121 Sh2b \$117 GND nfet_03v3 L=0.28U W=0.5U AS=0.18625P AD=0.2625P
+ PS=1.245U PD=2.05U
M$101 \$118 Sh4 \$117 GND nfet_03v3 L=0.28U W=0.5U AS=0.3775P AD=0.18625P
+ PS=2.51U PD=1.245U
M$102 \$122 Sh4b \$118 GND nfet_03v3 L=0.28U W=0.5U AS=0.18625P AD=0.2625P
+ PS=1.245U PD=2.05U
M$103 OUT4 Sh8 \$118 GND nfet_03v3 L=0.28U W=0.5U AS=0.3775P AD=0.18625P
+ PS=2.51U PD=1.245U
M$104 GND Sh8b OUT4 GND nfet_03v3 L=0.28U W=0.5U AS=0.18625P AD=0.2625P
+ PS=1.245U PD=2.05U
M$105 \$109 Sh1 A3 GND nfet_03v3 L=0.28U W=0.5U AS=0.3775P AD=0.18625P PS=2.51U
+ PD=1.245U
M$106 A2 Sh1b \$109 GND nfet_03v3 L=0.28U W=0.5U AS=0.18625P AD=0.2625P
+ PS=1.245U PD=2.05U
M$107 \$129 Sh2 \$109 GND nfet_03v3 L=0.28U W=0.5U AS=0.355P AD=0.18625P
+ PS=2.42U PD=1.245U
M$108 \$130 Sh2b \$129 GND nfet_03v3 L=0.28U W=0.5U AS=0.18625P AD=0.2625P
+ PS=1.245U PD=2.05U
M$109 \$60 Sh4 \$129 GND nfet_03v3 L=0.28U W=0.5U AS=0.3575P AD=0.18625P
+ PS=2.43U PD=1.245U
M$110 GND Sh4b \$60 GND nfet_03v3 L=0.28U W=0.5U AS=0.18625P AD=0.27P PS=1.245U
+ PD=2.08U
M$111 \$131 Sh8 \$60 GND nfet_03v3 L=0.28U W=0.5U AS=0.3575P AD=0.18625P
+ PS=2.43U PD=1.245U
M$112 GND Sh8b \$131 GND nfet_03v3 L=0.28U W=0.5U AS=0.18625P AD=0.27P
+ PS=1.245U PD=2.08U
M$113 \$127 \$131 GND GND nfet_03v3 L=0.28U W=0.5U AS=0.325P AD=0.2875P PS=2.3U
+ PD=2.15U
M$114 OUT3 \$127 GND GND nfet_03v3 L=0.28U W=0.5U AS=0.2975P AD=0.315P PS=2.19U
+ PD=2.26U
M$115 \$136 \$145 GND GND nfet_03v3 L=0.28U W=0.5U AS=0.325P AD=0.2875P PS=2.3U
+ PD=2.15U
M$116 OUT2 \$136 GND GND nfet_03v3 L=0.28U W=0.5U AS=0.2975P AD=0.315P PS=2.19U
+ PD=2.26U
M$117 \$121 Sh1 A2 GND nfet_03v3 L=0.28U W=0.5U AS=0.3775P AD=0.18625P PS=2.51U
+ PD=1.245U
M$118 A1 Sh1b \$121 GND nfet_03v3 L=0.28U W=0.5U AS=0.18625P AD=0.2625P
+ PS=1.245U PD=2.05U
M$119 \$144 Sh2 \$121 GND nfet_03v3 L=0.28U W=0.5U AS=0.3775P AD=0.18625P
+ PS=2.51U PD=1.245U
M$120 \$150 Sh2b \$144 GND nfet_03v3 L=0.28U W=0.5U AS=0.18625P AD=0.2625P
+ PS=1.245U PD=2.05U
M$121 \$67 Sh4 \$144 GND nfet_03v3 L=0.28U W=0.5U AS=0.3775P AD=0.18625P
+ PS=2.51U PD=1.245U
M$122 GND Sh4b \$67 GND nfet_03v3 L=0.28U W=0.5U AS=0.18625P AD=0.2625P
+ PS=1.245U PD=2.05U
M$123 \$145 Sh8 \$67 GND nfet_03v3 L=0.28U W=0.5U AS=0.3775P AD=0.18625P
+ PS=2.51U PD=1.245U
M$124 GND Sh8b \$145 GND nfet_03v3 L=0.28U W=0.5U AS=0.18625P AD=0.2625P
+ PS=1.245U PD=2.05U
M$125 \$130 Sh1 A1 GND nfet_03v3 L=0.28U W=0.5U AS=0.3775P AD=0.18625P PS=2.51U
+ PD=1.245U
M$126 A0 Sh1b \$130 GND nfet_03v3 L=0.28U W=0.5U AS=0.18625P AD=0.2625P
+ PS=1.245U PD=2.05U
M$127 \$110 Sh2 \$130 GND nfet_03v3 L=0.28U W=0.5U AS=0.355P AD=0.18625P
+ PS=2.42U PD=1.245U
M$128 GND Sh2b \$110 GND nfet_03v3 L=0.28U W=0.5U AS=0.18625P AD=0.2625P
+ PS=1.245U PD=2.05U
M$129 \$78 Sh4 \$110 GND nfet_03v3 L=0.28U W=0.5U AS=0.3575P AD=0.18625P
+ PS=2.43U PD=1.245U
M$130 GND Sh4b \$78 GND nfet_03v3 L=0.28U W=0.5U AS=0.18625P AD=0.27P PS=1.245U
+ PD=2.08U
M$131 \$158 Sh8 \$78 GND nfet_03v3 L=0.28U W=0.5U AS=0.3575P AD=0.18625P
+ PS=2.43U PD=1.245U
M$132 GND Sh8b \$158 GND nfet_03v3 L=0.28U W=0.5U AS=0.18625P AD=0.27P
+ PS=1.245U PD=2.08U
M$133 \$159 \$158 GND GND nfet_03v3 L=0.28U W=0.5U AS=0.325P AD=0.2875P PS=2.3U
+ PD=2.15U
M$134 OUT1 \$159 GND GND nfet_03v3 L=0.28U W=0.5U AS=0.2975P AD=0.315P PS=2.19U
+ PD=2.26U
M$135 \$171 \$170 GND GND nfet_03v3 L=0.28U W=0.5U AS=0.325P AD=0.2875P PS=2.3U
+ PD=2.15U
M$136 OUT0 \$171 GND GND nfet_03v3 L=0.28U W=0.5U AS=0.2975P AD=0.315P PS=2.19U
+ PD=2.26U
M$137 \$150 Sh1 A0 GND nfet_03v3 L=0.28U W=0.5U AS=0.3775P AD=0.18625P PS=2.51U
+ PD=1.245U
M$138 GND Sh1b \$150 GND nfet_03v3 L=0.28U W=0.5U AS=0.18625P AD=0.2625P
+ PS=1.245U PD=2.05U
M$139 \$122 Sh2 \$150 GND nfet_03v3 L=0.28U W=0.5U AS=0.3775P AD=0.18625P
+ PS=2.51U PD=1.245U
M$140 GND Sh2b \$122 GND nfet_03v3 L=0.28U W=0.5U AS=0.18625P AD=0.2625P
+ PS=1.245U PD=2.05U
M$141 \$94 Sh4 \$122 GND nfet_03v3 L=0.28U W=0.5U AS=0.3775P AD=0.18625P
+ PS=2.51U PD=1.245U
M$142 GND Sh4b \$94 GND nfet_03v3 L=0.28U W=0.5U AS=0.18625P AD=0.2625P
+ PS=1.245U PD=2.05U
M$143 \$170 Sh8 \$94 GND nfet_03v3 L=0.28U W=0.5U AS=0.3775P AD=0.18625P
+ PS=2.51U PD=1.245U
M$144 GND Sh8b \$170 GND nfet_03v3 L=0.28U W=0.5U AS=0.18625P AD=0.2625P
+ PS=1.245U PD=2.05U
.ENDS SHIFT
