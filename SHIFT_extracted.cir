* Extracted by KLayout with GF180MCU LVS runset on : 09/04/2026 04:12

.SUBCKT SHIFT A15 GND Sh1 Sh2 Sh4 Sh8 Sh1b A14 Sh2b Sh4b Sh8b OUT15 A13 OUT14
+ A12 OUT13 OUT12 A11 OUT11 A10 A9 OUT10 A8 OUT9 OUT8 A7 OUT7 A6 OUT6 VDD A5
+ OUT5 A4 OUT4 A3 OUT3 A2 OUT2 A1 OUT1 A0 OUT0
M$1 \$97 \$96 VDD VDD pfet_03v3 L=0.28U W=1U AS=0.65P AD=0.595P PS=3.3U PD=3.19U
M$2 OUT7 \$97 VDD VDD pfet_03v3 L=0.28U W=1U AS=0.595P AD=0.65P PS=3.19U PD=3.3U
M$3 \$111 \$116 VDD VDD pfet_03v3 L=0.28U W=1U AS=0.65P AD=0.595P PS=3.3U
+ PD=3.19U
M$4 OUT6 \$111 VDD VDD pfet_03v3 L=0.28U W=1U AS=0.595P AD=0.65P PS=3.19U
+ PD=3.3U
M$5 \$128 \$127 VDD VDD pfet_03v3 L=0.28U W=1U AS=0.65P AD=0.595P PS=3.3U
+ PD=3.19U
M$6 OUT5 \$128 VDD VDD pfet_03v3 L=0.28U W=1U AS=0.595P AD=0.65P PS=3.19U
+ PD=3.3U
M$7 \$143 \$142 VDD VDD pfet_03v3 L=0.28U W=1U AS=0.65P AD=0.595P PS=3.3U
+ PD=3.19U
M$8 OUT4 \$143 VDD VDD pfet_03v3 L=0.28U W=1U AS=0.595P AD=0.65P PS=3.19U
+ PD=3.3U
M$9 \$156 \$160 VDD VDD pfet_03v3 L=0.28U W=1U AS=0.65P AD=0.595P PS=3.3U
+ PD=3.19U
M$10 OUT3 \$156 VDD VDD pfet_03v3 L=0.28U W=1U AS=0.595P AD=0.65P PS=3.19U
+ PD=3.3U
M$11 \$164 \$172 VDD VDD pfet_03v3 L=0.28U W=1U AS=0.65P AD=0.595P PS=3.3U
+ PD=3.19U
M$12 OUT2 \$164 VDD VDD pfet_03v3 L=0.28U W=1U AS=0.595P AD=0.65P PS=3.19U
+ PD=3.3U
M$13 \$183 \$185 VDD VDD pfet_03v3 L=0.28U W=1U AS=0.65P AD=0.595P PS=3.3U
+ PD=3.19U
M$14 OUT1 \$183 VDD VDD pfet_03v3 L=0.28U W=1U AS=0.595P AD=0.65P PS=3.19U
+ PD=3.3U
M$15 \$196 \$200 VDD VDD pfet_03v3 L=0.28U W=1U AS=0.65P AD=0.595P PS=3.3U
+ PD=3.19U
M$16 OUT0 \$196 VDD VDD pfet_03v3 L=0.28U W=1U AS=0.595P AD=0.65P PS=3.19U
+ PD=3.3U
M$17 \$3 Sh1 A15 GND nfet_03v3 L=0.28U W=0.5U AS=0.3775P AD=0.18625P PS=2.51U
+ PD=1.245U
M$18 A14 Sh1b \$3 GND nfet_03v3 L=0.28U W=0.5U AS=0.18625P AD=0.2625P PS=1.245U
+ PD=2.05U
M$19 \$7 Sh2 \$3 GND nfet_03v3 L=0.28U W=0.5U AS=0.355P AD=0.18625P PS=2.42U
+ PD=1.245U
M$20 \$17 Sh2b \$7 GND nfet_03v3 L=0.28U W=0.5U AS=0.18625P AD=0.2625P
+ PS=1.245U PD=2.05U
M$21 \$10 Sh4 \$7 GND nfet_03v3 L=0.28U W=0.5U AS=0.3575P AD=0.18625P PS=2.43U
+ PD=1.245U
M$22 \$19 Sh4b \$10 GND nfet_03v3 L=0.28U W=0.5U AS=0.18625P AD=0.27P PS=1.245U
+ PD=2.08U
M$23 OUT15 Sh8 \$10 GND nfet_03v3 L=0.28U W=0.5U AS=0.3575P AD=0.18625P
+ PS=2.43U PD=1.245U
M$24 \$93 Sh8b OUT15 GND nfet_03v3 L=0.28U W=0.5U AS=0.18625P AD=0.27P
+ PS=1.245U PD=2.08U
M$25 \$4 Sh1 A14 GND nfet_03v3 L=0.28U W=0.5U AS=0.3775P AD=0.18625P PS=2.51U
+ PD=1.245U
M$26 A13 Sh1b \$4 GND nfet_03v3 L=0.28U W=0.5U AS=0.18625P AD=0.2625P PS=1.245U
+ PD=2.05U
M$27 \$27 Sh2 \$4 GND nfet_03v3 L=0.28U W=0.5U AS=0.3775P AD=0.18625P PS=2.51U
+ PD=1.245U
M$28 \$29 Sh2b \$27 GND nfet_03v3 L=0.28U W=0.5U AS=0.18625P AD=0.2625P
+ PS=1.245U PD=2.05U
M$29 \$30 Sh4 \$27 GND nfet_03v3 L=0.28U W=0.5U AS=0.3775P AD=0.18625P PS=2.51U
+ PD=1.245U
M$30 \$32 Sh4b \$30 GND nfet_03v3 L=0.28U W=0.5U AS=0.18625P AD=0.2625P
+ PS=1.245U PD=2.05U
M$31 OUT14 Sh8 \$30 GND nfet_03v3 L=0.28U W=0.5U AS=0.3775P AD=0.18625P
+ PS=2.51U PD=1.245U
M$32 \$115 Sh8b OUT14 GND nfet_03v3 L=0.28U W=0.5U AS=0.18625P AD=0.2625P
+ PS=1.245U PD=2.05U
M$33 \$17 Sh1 A13 GND nfet_03v3 L=0.28U W=0.5U AS=0.3775P AD=0.18625P PS=2.51U
+ PD=1.245U
M$34 A12 Sh1b \$17 GND nfet_03v3 L=0.28U W=0.5U AS=0.18625P AD=0.2625P
+ PS=1.245U PD=2.05U
M$35 \$5 Sh2 \$17 GND nfet_03v3 L=0.28U W=0.5U AS=0.355P AD=0.18625P PS=2.42U
+ PD=1.245U
M$36 \$38 Sh2b \$5 GND nfet_03v3 L=0.28U W=0.5U AS=0.18625P AD=0.2625P
+ PS=1.245U PD=2.05U
M$37 \$11 Sh4 \$5 GND nfet_03v3 L=0.28U W=0.5U AS=0.3575P AD=0.18625P PS=2.43U
+ PD=1.245U
M$38 \$39 Sh4b \$11 GND nfet_03v3 L=0.28U W=0.5U AS=0.18625P AD=0.27P PS=1.245U
+ PD=2.08U
M$39 OUT13 Sh8 \$11 GND nfet_03v3 L=0.28U W=0.5U AS=0.3575P AD=0.18625P
+ PS=2.43U PD=1.245U
M$40 \$94 Sh8b OUT13 GND nfet_03v3 L=0.28U W=0.5U AS=0.18625P AD=0.27P
+ PS=1.245U PD=2.08U
M$41 \$29 Sh1 A12 GND nfet_03v3 L=0.28U W=0.5U AS=0.3775P AD=0.18625P PS=2.51U
+ PD=1.245U
M$42 A11 Sh1b \$29 GND nfet_03v3 L=0.28U W=0.5U AS=0.18625P AD=0.2625P
+ PS=1.245U PD=2.05U
M$43 \$45 Sh2 \$29 GND nfet_03v3 L=0.28U W=0.5U AS=0.3775P AD=0.18625P PS=2.51U
+ PD=1.245U
M$44 \$49 Sh2b \$45 GND nfet_03v3 L=0.28U W=0.5U AS=0.18625P AD=0.2625P
+ PS=1.245U PD=2.05U
M$45 \$46 Sh4 \$45 GND nfet_03v3 L=0.28U W=0.5U AS=0.3775P AD=0.18625P PS=2.51U
+ PD=1.245U
M$46 \$80 Sh4b \$46 GND nfet_03v3 L=0.28U W=0.5U AS=0.18625P AD=0.2625P
+ PS=1.245U PD=2.05U
M$47 OUT12 Sh8 \$46 GND nfet_03v3 L=0.28U W=0.5U AS=0.3775P AD=0.18625P
+ PS=2.51U PD=1.245U
M$48 \$50 Sh8b OUT12 GND nfet_03v3 L=0.28U W=0.5U AS=0.18625P AD=0.2625P
+ PS=1.245U PD=2.05U
M$49 \$38 Sh1 A11 GND nfet_03v3 L=0.28U W=0.5U AS=0.3775P AD=0.18625P PS=2.51U
+ PD=1.245U
M$50 A10 Sh1b \$38 GND nfet_03v3 L=0.28U W=0.5U AS=0.18625P AD=0.2625P
+ PS=1.245U PD=2.05U
M$51 \$19 Sh2 \$38 GND nfet_03v3 L=0.28U W=0.5U AS=0.355P AD=0.18625P PS=2.42U
+ PD=1.245U
M$52 \$55 Sh2b \$19 GND nfet_03v3 L=0.28U W=0.5U AS=0.18625P AD=0.2625P
+ PS=1.245U PD=2.05U
M$53 \$12 Sh4 \$19 GND nfet_03v3 L=0.28U W=0.5U AS=0.3575P AD=0.18625P PS=2.43U
+ PD=1.245U
M$54 \$91 Sh4b \$12 GND nfet_03v3 L=0.28U W=0.5U AS=0.18625P AD=0.27P PS=1.245U
+ PD=2.08U
M$55 OUT11 Sh8 \$12 GND nfet_03v3 L=0.28U W=0.5U AS=0.3575P AD=0.18625P
+ PS=2.43U PD=1.245U
M$56 \$58 Sh8b OUT11 GND nfet_03v3 L=0.28U W=0.5U AS=0.18625P AD=0.27P
+ PS=1.245U PD=2.08U
M$57 \$49 Sh1 A10 GND nfet_03v3 L=0.28U W=0.5U AS=0.3775P AD=0.18625P PS=2.51U
+ PD=1.245U
M$58 A9 Sh1b \$49 GND nfet_03v3 L=0.28U W=0.5U AS=0.18625P AD=0.2625P PS=1.245U
+ PD=2.05U
M$59 \$32 Sh2 \$49 GND nfet_03v3 L=0.28U W=0.5U AS=0.3775P AD=0.18625P PS=2.51U
+ PD=1.245U
M$60 \$64 Sh2b \$32 GND nfet_03v3 L=0.28U W=0.5U AS=0.18625P AD=0.2625P
+ PS=1.245U PD=2.05U
M$61 \$13 Sh4 \$32 GND nfet_03v3 L=0.28U W=0.5U AS=0.3775P AD=0.18625P PS=2.51U
+ PD=1.245U
M$62 \$92 Sh4b \$13 GND nfet_03v3 L=0.28U W=0.5U AS=0.18625P AD=0.2625P
+ PS=1.245U PD=2.05U
M$63 OUT10 Sh8 \$13 GND nfet_03v3 L=0.28U W=0.5U AS=0.3775P AD=0.18625P
+ PS=2.51U PD=1.245U
M$64 \$65 Sh8b OUT10 GND nfet_03v3 L=0.28U W=0.5U AS=0.18625P AD=0.2625P
+ PS=1.245U PD=2.05U
M$65 \$55 Sh1 A9 GND nfet_03v3 L=0.28U W=0.5U AS=0.3775P AD=0.18625P PS=2.51U
+ PD=1.245U
M$66 A8 Sh1b \$55 GND nfet_03v3 L=0.28U W=0.5U AS=0.18625P AD=0.2625P PS=1.245U
+ PD=2.05U
M$67 \$39 Sh2 \$55 GND nfet_03v3 L=0.28U W=0.5U AS=0.355P AD=0.18625P PS=2.42U
+ PD=1.245U
M$68 \$95 Sh2b \$39 GND nfet_03v3 L=0.28U W=0.5U AS=0.18625P AD=0.2625P
+ PS=1.245U PD=2.05U
M$69 \$72 Sh4 \$39 GND nfet_03v3 L=0.28U W=0.5U AS=0.3575P AD=0.18625P PS=2.43U
+ PD=1.245U
M$70 \$74 Sh4b \$72 GND nfet_03v3 L=0.28U W=0.5U AS=0.18625P AD=0.27P PS=1.245U
+ PD=2.08U
M$71 OUT9 Sh8 \$72 GND nfet_03v3 L=0.28U W=0.5U AS=0.3575P AD=0.18625P PS=2.43U
+ PD=1.245U
M$72 \$75 Sh8b OUT9 GND nfet_03v3 L=0.28U W=0.5U AS=0.18625P AD=0.27P PS=1.245U
+ PD=2.08U
M$73 \$64 Sh1 A8 GND nfet_03v3 L=0.28U W=0.5U AS=0.3775P AD=0.18625P PS=2.51U
+ PD=1.245U
M$74 A7 Sh1b \$64 GND nfet_03v3 L=0.28U W=0.5U AS=0.18625P AD=0.2625P PS=1.245U
+ PD=2.05U
M$75 \$80 Sh2 \$64 GND nfet_03v3 L=0.28U W=0.5U AS=0.3775P AD=0.18625P PS=2.51U
+ PD=1.245U
M$76 \$83 Sh2b \$80 GND nfet_03v3 L=0.28U W=0.5U AS=0.18625P AD=0.2625P
+ PS=1.245U PD=2.05U
M$77 \$81 Sh4 \$80 GND nfet_03v3 L=0.28U W=0.5U AS=0.3775P AD=0.18625P PS=2.51U
+ PD=1.245U
M$78 \$84 Sh4b \$81 GND nfet_03v3 L=0.28U W=0.5U AS=0.18625P AD=0.2625P
+ PS=1.245U PD=2.05U
M$79 OUT8 Sh8 \$81 GND nfet_03v3 L=0.28U W=0.5U AS=0.3775P AD=0.18625P PS=2.51U
+ PD=1.245U
M$80 \$85 Sh8b OUT8 GND nfet_03v3 L=0.28U W=0.5U AS=0.18625P AD=0.2625P
+ PS=1.245U PD=2.05U
M$81 \$95 Sh1 A7 GND nfet_03v3 L=0.28U W=0.5U AS=0.3775P AD=0.18625P PS=2.51U
+ PD=1.245U
M$82 A6 Sh1b \$95 GND nfet_03v3 L=0.28U W=0.5U AS=0.18625P AD=0.2625P PS=1.245U
+ PD=2.05U
M$83 \$91 Sh2 \$95 GND nfet_03v3 L=0.28U W=0.5U AS=0.355P AD=0.18625P PS=2.42U
+ PD=1.245U
M$84 \$105 Sh2b \$91 GND nfet_03v3 L=0.28U W=0.5U AS=0.18625P AD=0.2625P
+ PS=1.245U PD=2.05U
M$85 \$93 Sh4 \$91 GND nfet_03v3 L=0.28U W=0.5U AS=0.3575P AD=0.18625P PS=2.43U
+ PD=1.245U
M$86 \$106 Sh4b \$93 GND nfet_03v3 L=0.28U W=0.5U AS=0.18625P AD=0.27P
+ PS=1.245U PD=2.08U
M$87 \$96 Sh8 \$93 GND nfet_03v3 L=0.28U W=0.5U AS=0.3575P AD=0.18625P PS=2.43U
+ PD=1.245U
M$88 GND Sh8b \$96 GND nfet_03v3 L=0.28U W=0.5U AS=0.18625P AD=0.27P PS=1.245U
+ PD=2.08U
M$89 \$97 \$96 GND GND nfet_03v3 L=0.28U W=0.5U AS=0.325P AD=0.2875P PS=2.3U
+ PD=2.15U
M$90 OUT7 \$97 GND GND nfet_03v3 L=0.28U W=0.5U AS=0.2975P AD=0.315P PS=2.19U
+ PD=2.26U
M$91 \$111 \$116 GND GND nfet_03v3 L=0.28U W=0.5U AS=0.325P AD=0.2875P PS=2.3U
+ PD=2.15U
M$92 OUT6 \$111 GND GND nfet_03v3 L=0.28U W=0.5U AS=0.2975P AD=0.315P PS=2.19U
+ PD=2.26U
M$93 \$83 Sh1 A6 GND nfet_03v3 L=0.28U W=0.5U AS=0.3775P AD=0.18625P PS=2.51U
+ PD=1.245U
M$94 A5 Sh1b \$83 GND nfet_03v3 L=0.28U W=0.5U AS=0.18625P AD=0.2625P PS=1.245U
+ PD=2.05U
M$95 \$92 Sh2 \$83 GND nfet_03v3 L=0.28U W=0.5U AS=0.3775P AD=0.18625P PS=2.51U
+ PD=1.245U
M$96 \$119 Sh2b \$92 GND nfet_03v3 L=0.28U W=0.5U AS=0.18625P AD=0.2625P
+ PS=1.245U PD=2.05U
M$97 \$115 Sh4 \$92 GND nfet_03v3 L=0.28U W=0.5U AS=0.3775P AD=0.18625P
+ PS=2.51U PD=1.245U
M$98 \$120 Sh4b \$115 GND nfet_03v3 L=0.28U W=0.5U AS=0.18625P AD=0.2625P
+ PS=1.245U PD=2.05U
M$99 \$116 Sh8 \$115 GND nfet_03v3 L=0.28U W=0.5U AS=0.3775P AD=0.18625P
+ PS=2.51U PD=1.245U
M$100 GND Sh8b \$116 GND nfet_03v3 L=0.28U W=0.5U AS=0.18625P AD=0.2625P
+ PS=1.245U PD=2.05U
M$101 \$105 Sh1 A5 GND nfet_03v3 L=0.28U W=0.5U AS=0.3775P AD=0.18625P PS=2.51U
+ PD=1.245U
M$102 A4 Sh1b \$105 GND nfet_03v3 L=0.28U W=0.5U AS=0.18625P AD=0.2625P
+ PS=1.245U PD=2.05U
M$103 \$74 Sh2 \$105 GND nfet_03v3 L=0.28U W=0.5U AS=0.355P AD=0.18625P
+ PS=2.42U PD=1.245U
M$104 \$134 Sh2b \$74 GND nfet_03v3 L=0.28U W=0.5U AS=0.18625P AD=0.2625P
+ PS=1.245U PD=2.05U
M$105 \$94 Sh4 \$74 GND nfet_03v3 L=0.28U W=0.5U AS=0.3575P AD=0.18625P
+ PS=2.43U PD=1.245U
M$106 \$135 Sh4b \$94 GND nfet_03v3 L=0.28U W=0.5U AS=0.18625P AD=0.27P
+ PS=1.245U PD=2.08U
M$107 \$127 Sh8 \$94 GND nfet_03v3 L=0.28U W=0.5U AS=0.3575P AD=0.18625P
+ PS=2.43U PD=1.245U
M$108 GND Sh8b \$127 GND nfet_03v3 L=0.28U W=0.5U AS=0.18625P AD=0.27P
+ PS=1.245U PD=2.08U
M$109 \$128 \$127 GND GND nfet_03v3 L=0.28U W=0.5U AS=0.325P AD=0.2875P PS=2.3U
+ PD=2.15U
M$110 OUT5 \$128 GND GND nfet_03v3 L=0.28U W=0.5U AS=0.2975P AD=0.315P PS=2.19U
+ PD=2.26U
M$111 \$143 \$142 GND GND nfet_03v3 L=0.28U W=0.5U AS=0.325P AD=0.2875P PS=2.3U
+ PD=2.15U
M$112 OUT4 \$143 GND GND nfet_03v3 L=0.28U W=0.5U AS=0.2975P AD=0.315P PS=2.19U
+ PD=2.26U
M$113 \$119 Sh1 A4 GND nfet_03v3 L=0.28U W=0.5U AS=0.3775P AD=0.18625P PS=2.51U
+ PD=1.245U
M$114 A3 Sh1b \$119 GND nfet_03v3 L=0.28U W=0.5U AS=0.18625P AD=0.2625P
+ PS=1.245U PD=2.05U
M$115 \$84 Sh2 \$119 GND nfet_03v3 L=0.28U W=0.5U AS=0.3775P AD=0.18625P
+ PS=2.51U PD=1.245U
M$116 \$148 Sh2b \$84 GND nfet_03v3 L=0.28U W=0.5U AS=0.18625P AD=0.2625P
+ PS=1.245U PD=2.05U
M$117 \$50 Sh4 \$84 GND nfet_03v3 L=0.28U W=0.5U AS=0.3775P AD=0.18625P
+ PS=2.51U PD=1.245U
M$118 \$149 Sh4b \$50 GND nfet_03v3 L=0.28U W=0.5U AS=0.18625P AD=0.2625P
+ PS=1.245U PD=2.05U
M$119 \$142 Sh8 \$50 GND nfet_03v3 L=0.28U W=0.5U AS=0.3775P AD=0.18625P
+ PS=2.51U PD=1.245U
M$120 GND Sh8b \$142 GND nfet_03v3 L=0.28U W=0.5U AS=0.18625P AD=0.2625P
+ PS=1.245U PD=2.05U
M$121 \$134 Sh1 A3 GND nfet_03v3 L=0.28U W=0.5U AS=0.3775P AD=0.18625P PS=2.51U
+ PD=1.245U
M$122 A2 Sh1b \$134 GND nfet_03v3 L=0.28U W=0.5U AS=0.18625P AD=0.2625P
+ PS=1.245U PD=2.05U
M$123 \$106 Sh2 \$134 GND nfet_03v3 L=0.28U W=0.5U AS=0.355P AD=0.18625P
+ PS=2.42U PD=1.245U
M$124 \$163 Sh2b \$106 GND nfet_03v3 L=0.28U W=0.5U AS=0.18625P AD=0.2625P
+ PS=1.245U PD=2.05U
M$125 \$58 Sh4 \$106 GND nfet_03v3 L=0.28U W=0.5U AS=0.3575P AD=0.18625P
+ PS=2.43U PD=1.245U
M$126 GND Sh4b \$58 GND nfet_03v3 L=0.28U W=0.5U AS=0.18625P AD=0.27P PS=1.245U
+ PD=2.08U
M$127 \$160 Sh8 \$58 GND nfet_03v3 L=0.28U W=0.5U AS=0.3575P AD=0.18625P
+ PS=2.43U PD=1.245U
M$128 GND Sh8b \$160 GND nfet_03v3 L=0.28U W=0.5U AS=0.18625P AD=0.27P
+ PS=1.245U PD=2.08U
M$129 \$156 \$160 GND GND nfet_03v3 L=0.28U W=0.5U AS=0.325P AD=0.2875P PS=2.3U
+ PD=2.15U
M$130 OUT3 \$156 GND GND nfet_03v3 L=0.28U W=0.5U AS=0.2975P AD=0.315P PS=2.19U
+ PD=2.26U
M$131 \$164 \$172 GND GND nfet_03v3 L=0.28U W=0.5U AS=0.325P AD=0.2875P PS=2.3U
+ PD=2.15U
M$132 OUT2 \$164 GND GND nfet_03v3 L=0.28U W=0.5U AS=0.2975P AD=0.315P PS=2.19U
+ PD=2.26U
M$133 \$148 Sh1 A2 GND nfet_03v3 L=0.28U W=0.5U AS=0.3775P AD=0.18625P PS=2.51U
+ PD=1.245U
M$134 A1 Sh1b \$148 GND nfet_03v3 L=0.28U W=0.5U AS=0.18625P AD=0.2625P
+ PS=1.245U PD=2.05U
M$135 \$120 Sh2 \$148 GND nfet_03v3 L=0.28U W=0.5U AS=0.3775P AD=0.18625P
+ PS=2.51U PD=1.245U
M$136 \$175 Sh2b \$120 GND nfet_03v3 L=0.28U W=0.5U AS=0.18625P AD=0.2625P
+ PS=1.245U PD=2.05U
M$137 \$65 Sh4 \$120 GND nfet_03v3 L=0.28U W=0.5U AS=0.3775P AD=0.18625P
+ PS=2.51U PD=1.245U
M$138 GND Sh4b \$65 GND nfet_03v3 L=0.28U W=0.5U AS=0.18625P AD=0.2625P
+ PS=1.245U PD=2.05U
M$139 \$172 Sh8 \$65 GND nfet_03v3 L=0.28U W=0.5U AS=0.3775P AD=0.18625P
+ PS=2.51U PD=1.245U
M$140 GND Sh8b \$172 GND nfet_03v3 L=0.28U W=0.5U AS=0.18625P AD=0.2625P
+ PS=1.245U PD=2.05U
M$141 \$163 Sh1 A1 GND nfet_03v3 L=0.28U W=0.5U AS=0.3775P AD=0.18625P PS=2.51U
+ PD=1.245U
M$142 A0 Sh1b \$163 GND nfet_03v3 L=0.28U W=0.5U AS=0.18625P AD=0.2625P
+ PS=1.245U PD=2.05U
M$143 \$135 Sh2 \$163 GND nfet_03v3 L=0.28U W=0.5U AS=0.355P AD=0.18625P
+ PS=2.42U PD=1.245U
M$144 GND Sh2b \$135 GND nfet_03v3 L=0.28U W=0.5U AS=0.18625P AD=0.2625P
+ PS=1.245U PD=2.05U
M$145 \$75 Sh4 \$135 GND nfet_03v3 L=0.28U W=0.5U AS=0.3575P AD=0.18625P
+ PS=2.43U PD=1.245U
M$146 GND Sh4b \$75 GND nfet_03v3 L=0.28U W=0.5U AS=0.18625P AD=0.27P PS=1.245U
+ PD=2.08U
M$147 \$185 Sh8 \$75 GND nfet_03v3 L=0.28U W=0.5U AS=0.3575P AD=0.18625P
+ PS=2.43U PD=1.245U
M$148 GND Sh8b \$185 GND nfet_03v3 L=0.28U W=0.5U AS=0.18625P AD=0.27P
+ PS=1.245U PD=2.08U
M$149 \$183 \$185 GND GND nfet_03v3 L=0.28U W=0.5U AS=0.325P AD=0.2875P PS=2.3U
+ PD=2.15U
M$150 OUT1 \$183 GND GND nfet_03v3 L=0.28U W=0.5U AS=0.2975P AD=0.315P PS=2.19U
+ PD=2.26U
M$151 \$196 \$200 GND GND nfet_03v3 L=0.28U W=0.5U AS=0.325P AD=0.2875P PS=2.3U
+ PD=2.15U
M$152 OUT0 \$196 GND GND nfet_03v3 L=0.28U W=0.5U AS=0.2975P AD=0.315P PS=2.19U
+ PD=2.26U
M$153 \$175 Sh1 A0 GND nfet_03v3 L=0.28U W=0.5U AS=0.3775P AD=0.18625P PS=2.51U
+ PD=1.245U
M$154 GND Sh1b \$175 GND nfet_03v3 L=0.28U W=0.5U AS=0.18625P AD=0.2625P
+ PS=1.245U PD=2.05U
M$155 \$149 Sh2 \$175 GND nfet_03v3 L=0.28U W=0.5U AS=0.3775P AD=0.18625P
+ PS=2.51U PD=1.245U
M$156 GND Sh2b \$149 GND nfet_03v3 L=0.28U W=0.5U AS=0.18625P AD=0.2625P
+ PS=1.245U PD=2.05U
M$157 \$85 Sh4 \$149 GND nfet_03v3 L=0.28U W=0.5U AS=0.3775P AD=0.18625P
+ PS=2.51U PD=1.245U
M$158 GND Sh4b \$85 GND nfet_03v3 L=0.28U W=0.5U AS=0.18625P AD=0.2625P
+ PS=1.245U PD=2.05U
M$159 \$200 Sh8 \$85 GND nfet_03v3 L=0.28U W=0.5U AS=0.3775P AD=0.18625P
+ PS=2.51U PD=1.245U
M$160 GND Sh8b \$200 GND nfet_03v3 L=0.28U W=0.5U AS=0.18625P AD=0.2625P
+ PS=1.245U PD=2.05U
.ENDS SHIFT
