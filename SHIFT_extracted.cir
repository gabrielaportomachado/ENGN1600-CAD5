* Extracted by KLayout with GF180MCU LVS runset on : 09/04/2026 04:29

.SUBCKT SHIFT A15 GND Sh1 Sh2 Sh4 Sh8 Sh1b A14 Sh2b Sh4b Sh8b OUT15 OUT14 A13
+ A12 OUT13 OUT12 A11 OUT11 A10 OUT10 A9 VDD OUT9 A8 OUT8 A7 OUT7 A6 OUT6 A5
+ OUT5 A4 OUT4 A3 OUT3 A2 OUT2 A1 OUT1 A0 OUT0
M$1 \$57 \$64 VDD VDD pfet_03v3 L=0.28U W=1U AS=0.65P AD=0.595P PS=3.3U PD=3.19U
M$2 OUT11 \$57 VDD VDD pfet_03v3 L=0.28U W=1U AS=0.595P AD=0.65P PS=3.19U
+ PD=3.3U
M$3 \$70 \$80 VDD VDD pfet_03v3 L=0.28U W=1U AS=0.65P AD=0.595P PS=3.3U PD=3.19U
M$4 OUT10 \$70 VDD VDD pfet_03v3 L=0.28U W=1U AS=0.595P AD=0.65P PS=3.19U
+ PD=3.3U
M$5 \$88 \$94 VDD VDD pfet_03v3 L=0.28U W=1U AS=0.65P AD=0.595P PS=3.3U PD=3.19U
M$6 OUT9 \$88 VDD VDD pfet_03v3 L=0.28U W=1U AS=0.595P AD=0.65P PS=3.19U PD=3.3U
M$7 \$104 \$110 VDD VDD pfet_03v3 L=0.28U W=1U AS=0.65P AD=0.595P PS=3.3U
+ PD=3.19U
M$8 OUT8 \$104 VDD VDD pfet_03v3 L=0.28U W=1U AS=0.595P AD=0.65P PS=3.19U
+ PD=3.3U
M$9 \$125 \$124 VDD VDD pfet_03v3 L=0.28U W=1U AS=0.65P AD=0.595P PS=3.3U
+ PD=3.19U
M$10 OUT7 \$125 VDD VDD pfet_03v3 L=0.28U W=1U AS=0.595P AD=0.65P PS=3.19U
+ PD=3.3U
M$11 \$135 \$141 VDD VDD pfet_03v3 L=0.28U W=1U AS=0.65P AD=0.595P PS=3.3U
+ PD=3.19U
M$12 OUT6 \$135 VDD VDD pfet_03v3 L=0.28U W=1U AS=0.595P AD=0.65P PS=3.19U
+ PD=3.3U
M$13 \$154 \$153 VDD VDD pfet_03v3 L=0.28U W=1U AS=0.65P AD=0.595P PS=3.3U
+ PD=3.19U
M$14 OUT5 \$154 VDD VDD pfet_03v3 L=0.28U W=1U AS=0.595P AD=0.65P PS=3.19U
+ PD=3.3U
M$15 \$163 \$169 VDD VDD pfet_03v3 L=0.28U W=1U AS=0.65P AD=0.595P PS=3.3U
+ PD=3.19U
M$16 OUT4 \$163 VDD VDD pfet_03v3 L=0.28U W=1U AS=0.595P AD=0.65P PS=3.19U
+ PD=3.3U
M$17 \$183 \$182 VDD VDD pfet_03v3 L=0.28U W=1U AS=0.65P AD=0.595P PS=3.3U
+ PD=3.19U
M$18 OUT3 \$183 VDD VDD pfet_03v3 L=0.28U W=1U AS=0.595P AD=0.65P PS=3.19U
+ PD=3.3U
M$19 \$196 \$198 VDD VDD pfet_03v3 L=0.28U W=1U AS=0.65P AD=0.595P PS=3.3U
+ PD=3.19U
M$20 OUT2 \$196 VDD VDD pfet_03v3 L=0.28U W=1U AS=0.595P AD=0.65P PS=3.19U
+ PD=3.3U
M$21 \$209 \$211 VDD VDD pfet_03v3 L=0.28U W=1U AS=0.65P AD=0.595P PS=3.3U
+ PD=3.19U
M$22 OUT1 \$209 VDD VDD pfet_03v3 L=0.28U W=1U AS=0.595P AD=0.65P PS=3.19U
+ PD=3.3U
M$23 \$222 \$226 VDD VDD pfet_03v3 L=0.28U W=1U AS=0.65P AD=0.595P PS=3.3U
+ PD=3.19U
M$24 OUT0 \$222 VDD VDD pfet_03v3 L=0.28U W=1U AS=0.595P AD=0.65P PS=3.19U
+ PD=3.3U
M$25 \$3 Sh1 A15 GND nfet_03v3 L=0.28U W=0.5U AS=0.3775P AD=0.18625P PS=2.51U
+ PD=1.245U
M$26 A14 Sh1b \$3 GND nfet_03v3 L=0.28U W=0.5U AS=0.18625P AD=0.2625P PS=1.245U
+ PD=2.05U
M$27 \$6 Sh2 \$3 GND nfet_03v3 L=0.28U W=0.5U AS=0.355P AD=0.18625P PS=2.42U
+ PD=1.245U
M$28 \$17 Sh2b \$6 GND nfet_03v3 L=0.28U W=0.5U AS=0.18625P AD=0.2625P
+ PS=1.245U PD=2.05U
M$29 \$9 Sh4 \$6 GND nfet_03v3 L=0.28U W=0.5U AS=0.3575P AD=0.18625P PS=2.43U
+ PD=1.245U
M$30 \$62 Sh4b \$9 GND nfet_03v3 L=0.28U W=0.5U AS=0.18625P AD=0.27P PS=1.245U
+ PD=2.08U
M$31 OUT15 Sh8 \$9 GND nfet_03v3 L=0.28U W=0.5U AS=0.3575P AD=0.18625P PS=2.43U
+ PD=1.245U
M$32 \$123 Sh8b OUT15 GND nfet_03v3 L=0.28U W=0.5U AS=0.18625P AD=0.27P
+ PS=1.245U PD=2.08U
M$33 \$4 Sh1 A14 GND nfet_03v3 L=0.28U W=0.5U AS=0.3775P AD=0.18625P PS=2.51U
+ PD=1.245U
M$34 A13 Sh1b \$4 GND nfet_03v3 L=0.28U W=0.5U AS=0.18625P AD=0.2625P PS=1.245U
+ PD=2.05U
M$35 \$26 Sh2 \$4 GND nfet_03v3 L=0.28U W=0.5U AS=0.3775P AD=0.18625P PS=2.51U
+ PD=1.245U
M$36 \$27 Sh2b \$26 GND nfet_03v3 L=0.28U W=0.5U AS=0.18625P AD=0.2625P
+ PS=1.245U PD=2.05U
M$37 \$28 Sh4 \$26 GND nfet_03v3 L=0.28U W=0.5U AS=0.3775P AD=0.18625P PS=2.51U
+ PD=1.245U
M$38 \$31 Sh4b \$28 GND nfet_03v3 L=0.28U W=0.5U AS=0.18625P AD=0.2625P
+ PS=1.245U PD=2.05U
M$39 OUT14 Sh8 \$28 GND nfet_03v3 L=0.28U W=0.5U AS=0.3775P AD=0.18625P
+ PS=2.51U PD=1.245U
M$40 \$32 Sh8b OUT14 GND nfet_03v3 L=0.28U W=0.5U AS=0.18625P AD=0.2625P
+ PS=1.245U PD=2.05U
M$41 \$17 Sh1 A13 GND nfet_03v3 L=0.28U W=0.5U AS=0.3775P AD=0.18625P PS=2.51U
+ PD=1.245U
M$42 A12 Sh1b \$17 GND nfet_03v3 L=0.28U W=0.5U AS=0.18625P AD=0.2625P
+ PS=1.245U PD=2.05U
M$43 \$37 Sh2 \$17 GND nfet_03v3 L=0.28U W=0.5U AS=0.355P AD=0.18625P PS=2.42U
+ PD=1.245U
M$44 \$56 Sh2b \$37 GND nfet_03v3 L=0.28U W=0.5U AS=0.18625P AD=0.2625P
+ PS=1.245U PD=2.05U
M$45 \$10 Sh4 \$37 GND nfet_03v3 L=0.28U W=0.5U AS=0.3575P AD=0.18625P PS=2.43U
+ PD=1.245U
M$46 \$39 Sh4b \$10 GND nfet_03v3 L=0.28U W=0.5U AS=0.18625P AD=0.27P PS=1.245U
+ PD=2.08U
M$47 OUT13 Sh8 \$10 GND nfet_03v3 L=0.28U W=0.5U AS=0.3575P AD=0.18625P
+ PS=2.43U PD=1.245U
M$48 \$40 Sh8b OUT13 GND nfet_03v3 L=0.28U W=0.5U AS=0.18625P AD=0.27P
+ PS=1.245U PD=2.08U
M$49 \$27 Sh1 A12 GND nfet_03v3 L=0.28U W=0.5U AS=0.3775P AD=0.18625P PS=2.51U
+ PD=1.245U
M$50 A11 Sh1b \$27 GND nfet_03v3 L=0.28U W=0.5U AS=0.18625P AD=0.2625P
+ PS=1.245U PD=2.05U
M$51 \$46 Sh2 \$27 GND nfet_03v3 L=0.28U W=0.5U AS=0.3775P AD=0.18625P PS=2.51U
+ PD=1.245U
M$52 \$49 Sh2b \$46 GND nfet_03v3 L=0.28U W=0.5U AS=0.18625P AD=0.2625P
+ PS=1.245U PD=2.05U
M$53 \$47 Sh4 \$46 GND nfet_03v3 L=0.28U W=0.5U AS=0.3775P AD=0.18625P PS=2.51U
+ PD=1.245U
M$54 \$50 Sh4b \$47 GND nfet_03v3 L=0.28U W=0.5U AS=0.18625P AD=0.2625P
+ PS=1.245U PD=2.05U
M$55 OUT12 Sh8 \$47 GND nfet_03v3 L=0.28U W=0.5U AS=0.3775P AD=0.18625P
+ PS=2.51U PD=1.245U
M$56 \$51 Sh8b OUT12 GND nfet_03v3 L=0.28U W=0.5U AS=0.18625P AD=0.2625P
+ PS=1.245U PD=2.05U
M$57 \$56 Sh1 A11 GND nfet_03v3 L=0.28U W=0.5U AS=0.3775P AD=0.18625P PS=2.51U
+ PD=1.245U
M$58 A10 Sh1b \$56 GND nfet_03v3 L=0.28U W=0.5U AS=0.18625P AD=0.2625P
+ PS=1.245U PD=2.05U
M$59 \$62 Sh2 \$56 GND nfet_03v3 L=0.28U W=0.5U AS=0.355P AD=0.18625P PS=2.42U
+ PD=1.245U
M$60 \$67 Sh2b \$62 GND nfet_03v3 L=0.28U W=0.5U AS=0.18625P AD=0.2625P
+ PS=1.245U PD=2.05U
M$61 \$63 Sh4 \$62 GND nfet_03v3 L=0.28U W=0.5U AS=0.3575P AD=0.18625P PS=2.43U
+ PD=1.245U
M$62 \$68 Sh4b \$63 GND nfet_03v3 L=0.28U W=0.5U AS=0.18625P AD=0.27P PS=1.245U
+ PD=2.08U
M$63 \$64 Sh8 \$63 GND nfet_03v3 L=0.28U W=0.5U AS=0.3575P AD=0.18625P PS=2.43U
+ PD=1.245U
M$64 \$69 Sh8b \$64 GND nfet_03v3 L=0.28U W=0.5U AS=0.18625P AD=0.27P PS=1.245U
+ PD=2.08U
M$65 \$57 \$64 GND GND nfet_03v3 L=0.28U W=0.5U AS=0.325P AD=0.2875P PS=2.3U
+ PD=2.15U
M$66 OUT11 \$57 GND GND nfet_03v3 L=0.28U W=0.5U AS=0.2975P AD=0.315P PS=2.19U
+ PD=2.26U
M$67 \$70 \$80 GND GND nfet_03v3 L=0.28U W=0.5U AS=0.325P AD=0.2875P PS=2.3U
+ PD=2.15U
M$68 OUT10 \$70 GND GND nfet_03v3 L=0.28U W=0.5U AS=0.2975P AD=0.315P PS=2.19U
+ PD=2.26U
M$69 \$49 Sh1 A10 GND nfet_03v3 L=0.28U W=0.5U AS=0.3775P AD=0.18625P PS=2.51U
+ PD=1.245U
M$70 A9 Sh1b \$49 GND nfet_03v3 L=0.28U W=0.5U AS=0.18625P AD=0.2625P PS=1.245U
+ PD=2.05U
M$71 \$31 Sh2 \$49 GND nfet_03v3 L=0.28U W=0.5U AS=0.3775P AD=0.18625P PS=2.51U
+ PD=1.245U
M$72 \$87 Sh2b \$31 GND nfet_03v3 L=0.28U W=0.5U AS=0.18625P AD=0.2625P
+ PS=1.245U PD=2.05U
M$73 \$11 Sh4 \$31 GND nfet_03v3 L=0.28U W=0.5U AS=0.3775P AD=0.18625P PS=2.51U
+ PD=1.245U
M$74 \$82 Sh4b \$11 GND nfet_03v3 L=0.28U W=0.5U AS=0.18625P AD=0.2625P
+ PS=1.245U PD=2.05U
M$75 \$80 Sh8 \$11 GND nfet_03v3 L=0.28U W=0.5U AS=0.3775P AD=0.18625P PS=2.51U
+ PD=1.245U
M$76 \$83 Sh8b \$80 GND nfet_03v3 L=0.28U W=0.5U AS=0.18625P AD=0.2625P
+ PS=1.245U PD=2.05U
M$77 \$67 Sh1 A9 GND nfet_03v3 L=0.28U W=0.5U AS=0.3775P AD=0.18625P PS=2.51U
+ PD=1.245U
M$78 A8 Sh1b \$67 GND nfet_03v3 L=0.28U W=0.5U AS=0.18625P AD=0.2625P PS=1.245U
+ PD=2.05U
M$79 \$39 Sh2 \$67 GND nfet_03v3 L=0.28U W=0.5U AS=0.355P AD=0.18625P PS=2.42U
+ PD=1.245U
M$80 \$101 Sh2b \$39 GND nfet_03v3 L=0.28U W=0.5U AS=0.18625P AD=0.2625P
+ PS=1.245U PD=2.05U
M$81 \$12 Sh4 \$39 GND nfet_03v3 L=0.28U W=0.5U AS=0.3575P AD=0.18625P PS=2.43U
+ PD=1.245U
M$82 \$102 Sh4b \$12 GND nfet_03v3 L=0.28U W=0.5U AS=0.18625P AD=0.27P
+ PS=1.245U PD=2.08U
M$83 \$94 Sh8 \$12 GND nfet_03v3 L=0.28U W=0.5U AS=0.3575P AD=0.18625P PS=2.43U
+ PD=1.245U
M$84 \$103 Sh8b \$94 GND nfet_03v3 L=0.28U W=0.5U AS=0.18625P AD=0.27P
+ PS=1.245U PD=2.08U
M$85 \$88 \$94 GND GND nfet_03v3 L=0.28U W=0.5U AS=0.325P AD=0.2875P PS=2.3U
+ PD=2.15U
M$86 OUT9 \$88 GND GND nfet_03v3 L=0.28U W=0.5U AS=0.2975P AD=0.315P PS=2.19U
+ PD=2.26U
M$87 \$104 \$110 GND GND nfet_03v3 L=0.28U W=0.5U AS=0.325P AD=0.2875P PS=2.3U
+ PD=2.15U
M$88 OUT8 \$104 GND GND nfet_03v3 L=0.28U W=0.5U AS=0.2975P AD=0.315P PS=2.19U
+ PD=2.26U
M$89 \$87 Sh1 A8 GND nfet_03v3 L=0.28U W=0.5U AS=0.3775P AD=0.18625P PS=2.51U
+ PD=1.245U
M$90 A7 Sh1b \$87 GND nfet_03v3 L=0.28U W=0.5U AS=0.18625P AD=0.2625P PS=1.245U
+ PD=2.05U
M$91 \$50 Sh2 \$87 GND nfet_03v3 L=0.28U W=0.5U AS=0.3775P AD=0.18625P PS=2.51U
+ PD=1.245U
M$92 \$114 Sh2b \$50 GND nfet_03v3 L=0.28U W=0.5U AS=0.18625P AD=0.2625P
+ PS=1.245U PD=2.05U
M$93 \$13 Sh4 \$50 GND nfet_03v3 L=0.28U W=0.5U AS=0.3775P AD=0.18625P PS=2.51U
+ PD=1.245U
M$94 \$115 Sh4b \$13 GND nfet_03v3 L=0.28U W=0.5U AS=0.18625P AD=0.2625P
+ PS=1.245U PD=2.05U
M$95 \$110 Sh8 \$13 GND nfet_03v3 L=0.28U W=0.5U AS=0.3775P AD=0.18625P
+ PS=2.51U PD=1.245U
M$96 \$116 Sh8b \$110 GND nfet_03v3 L=0.28U W=0.5U AS=0.18625P AD=0.2625P
+ PS=1.245U PD=2.05U
M$97 \$101 Sh1 A7 GND nfet_03v3 L=0.28U W=0.5U AS=0.3775P AD=0.18625P PS=2.51U
+ PD=1.245U
M$98 A6 Sh1b \$101 GND nfet_03v3 L=0.28U W=0.5U AS=0.18625P AD=0.2625P
+ PS=1.245U PD=2.05U
M$99 \$68 Sh2 \$101 GND nfet_03v3 L=0.28U W=0.5U AS=0.355P AD=0.18625P PS=2.42U
+ PD=1.245U
M$100 \$130 Sh2b \$68 GND nfet_03v3 L=0.28U W=0.5U AS=0.18625P AD=0.2625P
+ PS=1.245U PD=2.05U
M$101 \$123 Sh4 \$68 GND nfet_03v3 L=0.28U W=0.5U AS=0.3575P AD=0.18625P
+ PS=2.43U PD=1.245U
M$102 \$131 Sh4b \$123 GND nfet_03v3 L=0.28U W=0.5U AS=0.18625P AD=0.27P
+ PS=1.245U PD=2.08U
M$103 \$124 Sh8 \$123 GND nfet_03v3 L=0.28U W=0.5U AS=0.3575P AD=0.18625P
+ PS=2.43U PD=1.245U
M$104 GND Sh8b \$124 GND nfet_03v3 L=0.28U W=0.5U AS=0.18625P AD=0.27P
+ PS=1.245U PD=2.08U
M$105 \$125 \$124 GND GND nfet_03v3 L=0.28U W=0.5U AS=0.325P AD=0.2875P PS=2.3U
+ PD=2.15U
M$106 OUT7 \$125 GND GND nfet_03v3 L=0.28U W=0.5U AS=0.2975P AD=0.315P PS=2.19U
+ PD=2.26U
M$107 \$135 \$141 GND GND nfet_03v3 L=0.28U W=0.5U AS=0.325P AD=0.2875P PS=2.3U
+ PD=2.15U
M$108 OUT6 \$135 GND GND nfet_03v3 L=0.28U W=0.5U AS=0.2975P AD=0.315P PS=2.19U
+ PD=2.26U
M$109 \$114 Sh1 A6 GND nfet_03v3 L=0.28U W=0.5U AS=0.3775P AD=0.18625P PS=2.51U
+ PD=1.245U
M$110 A5 Sh1b \$114 GND nfet_03v3 L=0.28U W=0.5U AS=0.18625P AD=0.2625P
+ PS=1.245U PD=2.05U
M$111 \$82 Sh2 \$114 GND nfet_03v3 L=0.28U W=0.5U AS=0.3775P AD=0.18625P
+ PS=2.51U PD=1.245U
M$112 \$147 Sh2b \$82 GND nfet_03v3 L=0.28U W=0.5U AS=0.18625P AD=0.2625P
+ PS=1.245U PD=2.05U
M$113 \$32 Sh4 \$82 GND nfet_03v3 L=0.28U W=0.5U AS=0.3775P AD=0.18625P
+ PS=2.51U PD=1.245U
M$114 \$148 Sh4b \$32 GND nfet_03v3 L=0.28U W=0.5U AS=0.18625P AD=0.2625P
+ PS=1.245U PD=2.05U
M$115 \$141 Sh8 \$32 GND nfet_03v3 L=0.28U W=0.5U AS=0.3775P AD=0.18625P
+ PS=2.51U PD=1.245U
M$116 GND Sh8b \$141 GND nfet_03v3 L=0.28U W=0.5U AS=0.18625P AD=0.2625P
+ PS=1.245U PD=2.05U
M$117 \$130 Sh1 A5 GND nfet_03v3 L=0.28U W=0.5U AS=0.3775P AD=0.18625P PS=2.51U
+ PD=1.245U
M$118 A4 Sh1b \$130 GND nfet_03v3 L=0.28U W=0.5U AS=0.18625P AD=0.2625P
+ PS=1.245U PD=2.05U
M$119 \$102 Sh2 \$130 GND nfet_03v3 L=0.28U W=0.5U AS=0.355P AD=0.18625P
+ PS=2.42U PD=1.245U
M$120 \$174 Sh2b \$102 GND nfet_03v3 L=0.28U W=0.5U AS=0.18625P AD=0.2625P
+ PS=1.245U PD=2.05U
M$121 \$40 Sh4 \$102 GND nfet_03v3 L=0.28U W=0.5U AS=0.3575P AD=0.18625P
+ PS=2.43U PD=1.245U
M$122 \$160 Sh4b \$40 GND nfet_03v3 L=0.28U W=0.5U AS=0.18625P AD=0.27P
+ PS=1.245U PD=2.08U
M$123 \$153 Sh8 \$40 GND nfet_03v3 L=0.28U W=0.5U AS=0.3575P AD=0.18625P
+ PS=2.43U PD=1.245U
M$124 GND Sh8b \$153 GND nfet_03v3 L=0.28U W=0.5U AS=0.18625P AD=0.27P
+ PS=1.245U PD=2.08U
M$125 \$154 \$153 GND GND nfet_03v3 L=0.28U W=0.5U AS=0.325P AD=0.2875P PS=2.3U
+ PD=2.15U
M$126 OUT5 \$154 GND GND nfet_03v3 L=0.28U W=0.5U AS=0.2975P AD=0.315P PS=2.19U
+ PD=2.26U
M$127 \$163 \$169 GND GND nfet_03v3 L=0.28U W=0.5U AS=0.325P AD=0.2875P PS=2.3U
+ PD=2.15U
M$128 OUT4 \$163 GND GND nfet_03v3 L=0.28U W=0.5U AS=0.2975P AD=0.315P PS=2.19U
+ PD=2.26U
M$129 \$147 Sh1 A4 GND nfet_03v3 L=0.28U W=0.5U AS=0.3775P AD=0.18625P PS=2.51U
+ PD=1.245U
M$130 A3 Sh1b \$147 GND nfet_03v3 L=0.28U W=0.5U AS=0.18625P AD=0.2625P
+ PS=1.245U PD=2.05U
M$131 \$115 Sh2 \$147 GND nfet_03v3 L=0.28U W=0.5U AS=0.3775P AD=0.18625P
+ PS=2.51U PD=1.245U
M$132 \$173 Sh2b \$115 GND nfet_03v3 L=0.28U W=0.5U AS=0.18625P AD=0.2625P
+ PS=1.245U PD=2.05U
M$133 \$51 Sh4 \$115 GND nfet_03v3 L=0.28U W=0.5U AS=0.3775P AD=0.18625P
+ PS=2.51U PD=1.245U
M$134 \$175 Sh4b \$51 GND nfet_03v3 L=0.28U W=0.5U AS=0.18625P AD=0.2625P
+ PS=1.245U PD=2.05U
M$135 \$169 Sh8 \$51 GND nfet_03v3 L=0.28U W=0.5U AS=0.3775P AD=0.18625P
+ PS=2.51U PD=1.245U
M$136 GND Sh8b \$169 GND nfet_03v3 L=0.28U W=0.5U AS=0.18625P AD=0.2625P
+ PS=1.245U PD=2.05U
M$137 \$174 Sh1 A3 GND nfet_03v3 L=0.28U W=0.5U AS=0.3775P AD=0.18625P PS=2.51U
+ PD=1.245U
M$138 A2 Sh1b \$174 GND nfet_03v3 L=0.28U W=0.5U AS=0.18625P AD=0.2625P
+ PS=1.245U PD=2.05U
M$139 \$131 Sh2 \$174 GND nfet_03v3 L=0.28U W=0.5U AS=0.355P AD=0.18625P
+ PS=2.42U PD=1.245U
M$140 \$189 Sh2b \$131 GND nfet_03v3 L=0.28U W=0.5U AS=0.18625P AD=0.2625P
+ PS=1.245U PD=2.05U
M$141 \$69 Sh4 \$131 GND nfet_03v3 L=0.28U W=0.5U AS=0.3575P AD=0.18625P
+ PS=2.43U PD=1.245U
M$142 GND Sh4b \$69 GND nfet_03v3 L=0.28U W=0.5U AS=0.18625P AD=0.27P PS=1.245U
+ PD=2.08U
M$143 \$182 Sh8 \$69 GND nfet_03v3 L=0.28U W=0.5U AS=0.3575P AD=0.18625P
+ PS=2.43U PD=1.245U
M$144 GND Sh8b \$182 GND nfet_03v3 L=0.28U W=0.5U AS=0.18625P AD=0.27P
+ PS=1.245U PD=2.08U
M$145 \$183 \$182 GND GND nfet_03v3 L=0.28U W=0.5U AS=0.325P AD=0.2875P PS=2.3U
+ PD=2.15U
M$146 OUT3 \$183 GND GND nfet_03v3 L=0.28U W=0.5U AS=0.2975P AD=0.315P PS=2.19U
+ PD=2.26U
M$147 \$196 \$198 GND GND nfet_03v3 L=0.28U W=0.5U AS=0.325P AD=0.2875P PS=2.3U
+ PD=2.15U
M$148 OUT2 \$196 GND GND nfet_03v3 L=0.28U W=0.5U AS=0.2975P AD=0.315P PS=2.19U
+ PD=2.26U
M$149 \$173 Sh1 A2 GND nfet_03v3 L=0.28U W=0.5U AS=0.3775P AD=0.18625P PS=2.51U
+ PD=1.245U
M$150 A1 Sh1b \$173 GND nfet_03v3 L=0.28U W=0.5U AS=0.18625P AD=0.2625P
+ PS=1.245U PD=2.05U
M$151 \$148 Sh2 \$173 GND nfet_03v3 L=0.28U W=0.5U AS=0.3775P AD=0.18625P
+ PS=2.51U PD=1.245U
M$152 \$202 Sh2b \$148 GND nfet_03v3 L=0.28U W=0.5U AS=0.18625P AD=0.2625P
+ PS=1.245U PD=2.05U
M$153 \$83 Sh4 \$148 GND nfet_03v3 L=0.28U W=0.5U AS=0.3775P AD=0.18625P
+ PS=2.51U PD=1.245U
M$154 GND Sh4b \$83 GND nfet_03v3 L=0.28U W=0.5U AS=0.18625P AD=0.2625P
+ PS=1.245U PD=2.05U
M$155 \$198 Sh8 \$83 GND nfet_03v3 L=0.28U W=0.5U AS=0.3775P AD=0.18625P
+ PS=2.51U PD=1.245U
M$156 GND Sh8b \$198 GND nfet_03v3 L=0.28U W=0.5U AS=0.18625P AD=0.2625P
+ PS=1.245U PD=2.05U
M$157 \$189 Sh1 A1 GND nfet_03v3 L=0.28U W=0.5U AS=0.3775P AD=0.18625P PS=2.51U
+ PD=1.245U
M$158 A0 Sh1b \$189 GND nfet_03v3 L=0.28U W=0.5U AS=0.18625P AD=0.2625P
+ PS=1.245U PD=2.05U
M$159 \$160 Sh2 \$189 GND nfet_03v3 L=0.28U W=0.5U AS=0.355P AD=0.18625P
+ PS=2.42U PD=1.245U
M$160 GND Sh2b \$160 GND nfet_03v3 L=0.28U W=0.5U AS=0.18625P AD=0.2625P
+ PS=1.245U PD=2.05U
M$161 \$103 Sh4 \$160 GND nfet_03v3 L=0.28U W=0.5U AS=0.3575P AD=0.18625P
+ PS=2.43U PD=1.245U
M$162 GND Sh4b \$103 GND nfet_03v3 L=0.28U W=0.5U AS=0.18625P AD=0.27P
+ PS=1.245U PD=2.08U
M$163 \$211 Sh8 \$103 GND nfet_03v3 L=0.28U W=0.5U AS=0.3575P AD=0.18625P
+ PS=2.43U PD=1.245U
M$164 GND Sh8b \$211 GND nfet_03v3 L=0.28U W=0.5U AS=0.18625P AD=0.27P
+ PS=1.245U PD=2.08U
M$165 \$209 \$211 GND GND nfet_03v3 L=0.28U W=0.5U AS=0.325P AD=0.2875P PS=2.3U
+ PD=2.15U
M$166 OUT1 \$209 GND GND nfet_03v3 L=0.28U W=0.5U AS=0.2975P AD=0.315P PS=2.19U
+ PD=2.26U
M$167 \$222 \$226 GND GND nfet_03v3 L=0.28U W=0.5U AS=0.325P AD=0.2875P PS=2.3U
+ PD=2.15U
M$168 OUT0 \$222 GND GND nfet_03v3 L=0.28U W=0.5U AS=0.2975P AD=0.315P PS=2.19U
+ PD=2.26U
M$169 \$202 Sh1 A0 GND nfet_03v3 L=0.28U W=0.5U AS=0.3775P AD=0.18625P PS=2.51U
+ PD=1.245U
M$170 GND Sh1b \$202 GND nfet_03v3 L=0.28U W=0.5U AS=0.18625P AD=0.2625P
+ PS=1.245U PD=2.05U
M$171 \$175 Sh2 \$202 GND nfet_03v3 L=0.28U W=0.5U AS=0.3775P AD=0.18625P
+ PS=2.51U PD=1.245U
M$172 GND Sh2b \$175 GND nfet_03v3 L=0.28U W=0.5U AS=0.18625P AD=0.2625P
+ PS=1.245U PD=2.05U
M$173 \$116 Sh4 \$175 GND nfet_03v3 L=0.28U W=0.5U AS=0.3775P AD=0.18625P
+ PS=2.51U PD=1.245U
M$174 GND Sh4b \$116 GND nfet_03v3 L=0.28U W=0.5U AS=0.18625P AD=0.2625P
+ PS=1.245U PD=2.05U
M$175 \$226 Sh8 \$116 GND nfet_03v3 L=0.28U W=0.5U AS=0.3775P AD=0.18625P
+ PS=2.51U PD=1.245U
M$176 GND Sh8b \$226 GND nfet_03v3 L=0.28U W=0.5U AS=0.18625P AD=0.2625P
+ PS=1.245U PD=2.05U
.ENDS SHIFT
