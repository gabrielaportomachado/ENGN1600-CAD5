* Extracted by KLayout with GF180MCU LVS runset on : 09/04/2026 04:41

.SUBCKT SHIFT OUT15 A15 GND Sh1 Sh2 Sh1b A14 Sh2b Sh4b Sh4 Sh8b Sh8 OUT14 VDD
+ A13 OUT13 A12 OUT12 A11 OUT11 OUT10 A10 A9 OUT9 A8 OUT8 A7 OUT7 A6 OUT6 A5
+ OUT5 A4 OUT4 A3 OUT3 A2 OUT2 A1 OUT1 A0 OUT0
M$1 \$1 \$15 VDD VDD pfet_03v3 L=0.28U W=1U AS=0.65P AD=0.595P PS=3.3U PD=3.19U
M$2 OUT15 \$1 VDD VDD pfet_03v3 L=0.28U W=1U AS=0.595P AD=0.65P PS=3.19U PD=3.3U
M$3 \$25 \$31 VDD VDD pfet_03v3 L=0.28U W=1U AS=0.65P AD=0.595P PS=3.3U PD=3.19U
M$4 OUT14 \$25 VDD VDD pfet_03v3 L=0.28U W=1U AS=0.595P AD=0.65P PS=3.19U
+ PD=3.3U
M$5 \$46 \$52 VDD VDD pfet_03v3 L=0.28U W=1U AS=0.65P AD=0.595P PS=3.3U PD=3.19U
M$6 OUT13 \$46 VDD VDD pfet_03v3 L=0.28U W=1U AS=0.595P AD=0.65P PS=3.19U
+ PD=3.3U
M$7 \$61 \$70 VDD VDD pfet_03v3 L=0.28U W=1U AS=0.65P AD=0.595P PS=3.3U PD=3.19U
M$8 OUT12 \$61 VDD VDD pfet_03v3 L=0.28U W=1U AS=0.595P AD=0.65P PS=3.19U
+ PD=3.3U
M$9 \$83 \$82 VDD VDD pfet_03v3 L=0.28U W=1U AS=0.65P AD=0.595P PS=3.3U PD=3.19U
M$10 OUT11 \$83 VDD VDD pfet_03v3 L=0.28U W=1U AS=0.595P AD=0.65P PS=3.19U
+ PD=3.3U
M$11 \$91 \$97 VDD VDD pfet_03v3 L=0.28U W=1U AS=0.65P AD=0.595P PS=3.3U
+ PD=3.19U
M$12 OUT10 \$91 VDD VDD pfet_03v3 L=0.28U W=1U AS=0.595P AD=0.65P PS=3.19U
+ PD=3.3U
M$13 \$113 \$119 VDD VDD pfet_03v3 L=0.28U W=1U AS=0.65P AD=0.595P PS=3.3U
+ PD=3.19U
M$14 OUT9 \$113 VDD VDD pfet_03v3 L=0.28U W=1U AS=0.595P AD=0.65P PS=3.19U
+ PD=3.3U
M$15 \$124 \$134 VDD VDD pfet_03v3 L=0.28U W=1U AS=0.65P AD=0.595P PS=3.3U
+ PD=3.19U
M$16 OUT8 \$124 VDD VDD pfet_03v3 L=0.28U W=1U AS=0.595P AD=0.65P PS=3.19U
+ PD=3.3U
M$17 \$151 \$150 VDD VDD pfet_03v3 L=0.28U W=1U AS=0.65P AD=0.595P PS=3.3U
+ PD=3.19U
M$18 OUT7 \$151 VDD VDD pfet_03v3 L=0.28U W=1U AS=0.595P AD=0.65P PS=3.19U
+ PD=3.3U
M$19 \$161 \$167 VDD VDD pfet_03v3 L=0.28U W=1U AS=0.65P AD=0.595P PS=3.3U
+ PD=3.19U
M$20 OUT6 \$161 VDD VDD pfet_03v3 L=0.28U W=1U AS=0.595P AD=0.65P PS=3.19U
+ PD=3.3U
M$21 \$179 \$178 VDD VDD pfet_03v3 L=0.28U W=1U AS=0.65P AD=0.595P PS=3.3U
+ PD=3.19U
M$22 OUT5 \$179 VDD VDD pfet_03v3 L=0.28U W=1U AS=0.595P AD=0.65P PS=3.19U
+ PD=3.3U
M$23 \$193 \$192 VDD VDD pfet_03v3 L=0.28U W=1U AS=0.65P AD=0.595P PS=3.3U
+ PD=3.19U
M$24 OUT4 \$193 VDD VDD pfet_03v3 L=0.28U W=1U AS=0.595P AD=0.65P PS=3.19U
+ PD=3.3U
M$25 \$209 \$208 VDD VDD pfet_03v3 L=0.28U W=1U AS=0.65P AD=0.595P PS=3.3U
+ PD=3.19U
M$26 OUT3 \$209 VDD VDD pfet_03v3 L=0.28U W=1U AS=0.595P AD=0.65P PS=3.19U
+ PD=3.3U
M$27 \$216 \$224 VDD VDD pfet_03v3 L=0.28U W=1U AS=0.65P AD=0.595P PS=3.3U
+ PD=3.19U
M$28 OUT2 \$216 VDD VDD pfet_03v3 L=0.28U W=1U AS=0.595P AD=0.65P PS=3.19U
+ PD=3.3U
M$29 \$235 \$239 VDD VDD pfet_03v3 L=0.28U W=1U AS=0.65P AD=0.595P PS=3.3U
+ PD=3.19U
M$30 OUT1 \$235 VDD VDD pfet_03v3 L=0.28U W=1U AS=0.595P AD=0.65P PS=3.19U
+ PD=3.3U
M$31 \$248 \$252 VDD VDD pfet_03v3 L=0.28U W=1U AS=0.65P AD=0.595P PS=3.3U
+ PD=3.19U
M$32 OUT0 \$248 VDD VDD pfet_03v3 L=0.28U W=1U AS=0.595P AD=0.65P PS=3.19U
+ PD=3.3U
M$33 \$1 \$15 GND GND nfet_03v3 L=0.28U W=0.5U AS=0.325P AD=0.2875P PS=2.3U
+ PD=2.15U
M$34 OUT15 \$1 GND GND nfet_03v3 L=0.28U W=0.5U AS=0.2975P AD=0.315P PS=2.19U
+ PD=2.26U
M$35 \$5 Sh1 A15 GND nfet_03v3 L=0.28U W=0.5U AS=0.3775P AD=0.18625P PS=2.51U
+ PD=1.245U
M$36 A14 Sh1b \$5 GND nfet_03v3 L=0.28U W=0.5U AS=0.18625P AD=0.2625P PS=1.245U
+ PD=2.05U
M$37 \$7 Sh2 \$5 GND nfet_03v3 L=0.28U W=0.5U AS=0.355P AD=0.18625P PS=2.42U
+ PD=1.245U
M$38 \$43 Sh2b \$7 GND nfet_03v3 L=0.28U W=0.5U AS=0.18625P AD=0.2625P
+ PS=1.245U PD=2.05U
M$39 \$12 Sh4 \$7 GND nfet_03v3 L=0.28U W=0.5U AS=0.3575P AD=0.18625P PS=2.43U
+ PD=1.245U
M$40 \$21 Sh4b \$12 GND nfet_03v3 L=0.28U W=0.5U AS=0.18625P AD=0.27P PS=1.245U
+ PD=2.08U
M$41 \$15 Sh8 \$12 GND nfet_03v3 L=0.28U W=0.5U AS=0.3575P AD=0.18625P PS=2.43U
+ PD=1.245U
M$42 \$30 Sh8b \$15 GND nfet_03v3 L=0.28U W=0.5U AS=0.18625P AD=0.27P PS=1.245U
+ PD=2.08U
M$43 \$25 \$31 GND GND nfet_03v3 L=0.28U W=0.5U AS=0.325P AD=0.2875P PS=2.3U
+ PD=2.15U
M$44 OUT14 \$25 GND GND nfet_03v3 L=0.28U W=0.5U AS=0.2975P AD=0.315P PS=2.19U
+ PD=2.26U
M$45 \$6 Sh1 A14 GND nfet_03v3 L=0.28U W=0.5U AS=0.3775P AD=0.18625P PS=2.51U
+ PD=1.245U
M$46 A13 Sh1b \$6 GND nfet_03v3 L=0.28U W=0.5U AS=0.18625P AD=0.2625P PS=1.245U
+ PD=2.05U
M$47 \$29 Sh2 \$6 GND nfet_03v3 L=0.28U W=0.5U AS=0.3775P AD=0.18625P PS=2.51U
+ PD=1.245U
M$48 \$44 Sh2b \$29 GND nfet_03v3 L=0.28U W=0.5U AS=0.18625P AD=0.2625P
+ PS=1.245U PD=2.05U
M$49 \$38 Sh4 \$29 GND nfet_03v3 L=0.28U W=0.5U AS=0.3775P AD=0.18625P PS=2.51U
+ PD=1.245U
M$50 \$101 Sh4b \$38 GND nfet_03v3 L=0.28U W=0.5U AS=0.18625P AD=0.2625P
+ PS=1.245U PD=2.05U
M$51 \$31 Sh8 \$38 GND nfet_03v3 L=0.28U W=0.5U AS=0.3775P AD=0.18625P PS=2.51U
+ PD=1.245U
M$52 \$45 Sh8b \$31 GND nfet_03v3 L=0.28U W=0.5U AS=0.18625P AD=0.2625P
+ PS=1.245U PD=2.05U
M$53 \$46 \$52 GND GND nfet_03v3 L=0.28U W=0.5U AS=0.325P AD=0.2875P PS=2.3U
+ PD=2.15U
M$54 OUT13 \$46 GND GND nfet_03v3 L=0.28U W=0.5U AS=0.2975P AD=0.315P PS=2.19U
+ PD=2.26U
M$55 \$43 Sh1 A13 GND nfet_03v3 L=0.28U W=0.5U AS=0.3775P AD=0.18625P PS=2.51U
+ PD=1.245U
M$56 A12 Sh1b \$43 GND nfet_03v3 L=0.28U W=0.5U AS=0.18625P AD=0.2625P
+ PS=1.245U PD=2.05U
M$57 \$51 Sh2 \$43 GND nfet_03v3 L=0.28U W=0.5U AS=0.355P AD=0.18625P PS=2.42U
+ PD=1.245U
M$58 \$60 Sh2b \$51 GND nfet_03v3 L=0.28U W=0.5U AS=0.18625P AD=0.2625P
+ PS=1.245U PD=2.05U
M$59 \$13 Sh4 \$51 GND nfet_03v3 L=0.28U W=0.5U AS=0.3575P AD=0.18625P PS=2.43U
+ PD=1.245U
M$60 \$117 Sh4b \$13 GND nfet_03v3 L=0.28U W=0.5U AS=0.18625P AD=0.27P
+ PS=1.245U PD=2.08U
M$61 \$52 Sh8 \$13 GND nfet_03v3 L=0.28U W=0.5U AS=0.3575P AD=0.18625P PS=2.43U
+ PD=1.245U
M$62 \$148 Sh8b \$52 GND nfet_03v3 L=0.28U W=0.5U AS=0.18625P AD=0.27P
+ PS=1.245U PD=2.08U
M$63 \$61 \$70 GND GND nfet_03v3 L=0.28U W=0.5U AS=0.325P AD=0.2875P PS=2.3U
+ PD=2.15U
M$64 OUT12 \$61 GND GND nfet_03v3 L=0.28U W=0.5U AS=0.2975P AD=0.315P PS=2.19U
+ PD=2.26U
M$65 \$44 Sh1 A12 GND nfet_03v3 L=0.28U W=0.5U AS=0.3775P AD=0.18625P PS=2.51U
+ PD=1.245U
M$66 A11 Sh1b \$44 GND nfet_03v3 L=0.28U W=0.5U AS=0.18625P AD=0.2625P
+ PS=1.245U PD=2.05U
M$67 \$69 Sh2 \$44 GND nfet_03v3 L=0.28U W=0.5U AS=0.3775P AD=0.18625P PS=2.51U
+ PD=1.245U
M$68 \$75 Sh2b \$69 GND nfet_03v3 L=0.28U W=0.5U AS=0.18625P AD=0.2625P
+ PS=1.245U PD=2.05U
M$69 \$71 Sh4 \$69 GND nfet_03v3 L=0.28U W=0.5U AS=0.3775P AD=0.18625P PS=2.51U
+ PD=1.245U
M$70 \$76 Sh4b \$71 GND nfet_03v3 L=0.28U W=0.5U AS=0.18625P AD=0.2625P
+ PS=1.245U PD=2.05U
M$71 \$70 Sh8 \$71 GND nfet_03v3 L=0.28U W=0.5U AS=0.3775P AD=0.18625P PS=2.51U
+ PD=1.245U
M$72 \$77 Sh8b \$70 GND nfet_03v3 L=0.28U W=0.5U AS=0.18625P AD=0.2625P
+ PS=1.245U PD=2.05U
M$73 \$60 Sh1 A11 GND nfet_03v3 L=0.28U W=0.5U AS=0.3775P AD=0.18625P PS=2.51U
+ PD=1.245U
M$74 A10 Sh1b \$60 GND nfet_03v3 L=0.28U W=0.5U AS=0.18625P AD=0.2625P
+ PS=1.245U PD=2.05U
M$75 \$21 Sh2 \$60 GND nfet_03v3 L=0.28U W=0.5U AS=0.355P AD=0.18625P PS=2.42U
+ PD=1.245U
M$76 \$112 Sh2b \$21 GND nfet_03v3 L=0.28U W=0.5U AS=0.18625P AD=0.2625P
+ PS=1.245U PD=2.05U
M$77 \$14 Sh4 \$21 GND nfet_03v3 L=0.28U W=0.5U AS=0.3575P AD=0.18625P PS=2.43U
+ PD=1.245U
M$78 \$147 Sh4b \$14 GND nfet_03v3 L=0.28U W=0.5U AS=0.18625P AD=0.27P
+ PS=1.245U PD=2.08U
M$79 \$82 Sh8 \$14 GND nfet_03v3 L=0.28U W=0.5U AS=0.3575P AD=0.18625P PS=2.43U
+ PD=1.245U
M$80 \$90 Sh8b \$82 GND nfet_03v3 L=0.28U W=0.5U AS=0.18625P AD=0.27P PS=1.245U
+ PD=2.08U
M$81 \$83 \$82 GND GND nfet_03v3 L=0.28U W=0.5U AS=0.325P AD=0.2875P PS=2.3U
+ PD=2.15U
M$82 OUT11 \$83 GND GND nfet_03v3 L=0.28U W=0.5U AS=0.2975P AD=0.315P PS=2.19U
+ PD=2.26U
M$83 \$91 \$97 GND GND nfet_03v3 L=0.28U W=0.5U AS=0.325P AD=0.2875P PS=2.3U
+ PD=2.15U
M$84 OUT10 \$91 GND GND nfet_03v3 L=0.28U W=0.5U AS=0.2975P AD=0.315P PS=2.19U
+ PD=2.26U
M$85 \$75 Sh1 A10 GND nfet_03v3 L=0.28U W=0.5U AS=0.3775P AD=0.18625P PS=2.51U
+ PD=1.245U
M$86 A9 Sh1b \$75 GND nfet_03v3 L=0.28U W=0.5U AS=0.18625P AD=0.2625P PS=1.245U
+ PD=2.05U
M$87 \$101 Sh2 \$75 GND nfet_03v3 L=0.28U W=0.5U AS=0.3775P AD=0.18625P
+ PS=2.51U PD=1.245U
M$88 \$106 Sh2b \$101 GND nfet_03v3 L=0.28U W=0.5U AS=0.18625P AD=0.2625P
+ PS=1.245U PD=2.05U
M$89 \$102 Sh4 \$101 GND nfet_03v3 L=0.28U W=0.5U AS=0.3775P AD=0.18625P
+ PS=2.51U PD=1.245U
M$90 \$107 Sh4b \$102 GND nfet_03v3 L=0.28U W=0.5U AS=0.18625P AD=0.2625P
+ PS=1.245U PD=2.05U
M$91 \$97 Sh8 \$102 GND nfet_03v3 L=0.28U W=0.5U AS=0.3775P AD=0.18625P
+ PS=2.51U PD=1.245U
M$92 \$149 Sh8b \$97 GND nfet_03v3 L=0.28U W=0.5U AS=0.18625P AD=0.2625P
+ PS=1.245U PD=2.05U
M$93 \$112 Sh1 A9 GND nfet_03v3 L=0.28U W=0.5U AS=0.3775P AD=0.18625P PS=2.51U
+ PD=1.245U
M$94 A8 Sh1b \$112 GND nfet_03v3 L=0.28U W=0.5U AS=0.18625P AD=0.2625P
+ PS=1.245U PD=2.05U
M$95 \$117 Sh2 \$112 GND nfet_03v3 L=0.28U W=0.5U AS=0.355P AD=0.18625P
+ PS=2.42U PD=1.245U
M$96 \$146 Sh2b \$117 GND nfet_03v3 L=0.28U W=0.5U AS=0.18625P AD=0.2625P
+ PS=1.245U PD=2.05U
M$97 \$118 Sh4 \$117 GND nfet_03v3 L=0.28U W=0.5U AS=0.3575P AD=0.18625P
+ PS=2.43U PD=1.245U
M$98 \$122 Sh4b \$118 GND nfet_03v3 L=0.28U W=0.5U AS=0.18625P AD=0.27P
+ PS=1.245U PD=2.08U
M$99 \$119 Sh8 \$118 GND nfet_03v3 L=0.28U W=0.5U AS=0.3575P AD=0.18625P
+ PS=2.43U PD=1.245U
M$100 \$123 Sh8b \$119 GND nfet_03v3 L=0.28U W=0.5U AS=0.18625P AD=0.27P
+ PS=1.245U PD=2.08U
M$101 \$113 \$119 GND GND nfet_03v3 L=0.28U W=0.5U AS=0.325P AD=0.2875P PS=2.3U
+ PD=2.15U
M$102 OUT9 \$113 GND GND nfet_03v3 L=0.28U W=0.5U AS=0.2975P AD=0.315P PS=2.19U
+ PD=2.26U
M$103 \$124 \$134 GND GND nfet_03v3 L=0.28U W=0.5U AS=0.325P AD=0.2875P PS=2.3U
+ PD=2.15U
M$104 OUT8 \$124 GND GND nfet_03v3 L=0.28U W=0.5U AS=0.2975P AD=0.315P PS=2.19U
+ PD=2.26U
M$105 \$106 Sh1 A8 GND nfet_03v3 L=0.28U W=0.5U AS=0.3775P AD=0.18625P PS=2.51U
+ PD=1.245U
M$106 A7 Sh1b \$106 GND nfet_03v3 L=0.28U W=0.5U AS=0.18625P AD=0.2625P
+ PS=1.245U PD=2.05U
M$107 \$76 Sh2 \$106 GND nfet_03v3 L=0.28U W=0.5U AS=0.3775P AD=0.18625P
+ PS=2.51U PD=1.245U
M$108 \$136 Sh2b \$76 GND nfet_03v3 L=0.28U W=0.5U AS=0.18625P AD=0.2625P
+ PS=1.245U PD=2.05U
M$109 \$137 Sh4 \$76 GND nfet_03v3 L=0.28U W=0.5U AS=0.3775P AD=0.18625P
+ PS=2.51U PD=1.245U
M$110 \$138 Sh4b \$137 GND nfet_03v3 L=0.28U W=0.5U AS=0.18625P AD=0.2625P
+ PS=1.245U PD=2.05U
M$111 \$134 Sh8 \$137 GND nfet_03v3 L=0.28U W=0.5U AS=0.3775P AD=0.18625P
+ PS=2.51U PD=1.245U
M$112 \$139 Sh8b \$134 GND nfet_03v3 L=0.28U W=0.5U AS=0.18625P AD=0.2625P
+ PS=1.245U PD=2.05U
M$113 \$146 Sh1 A7 GND nfet_03v3 L=0.28U W=0.5U AS=0.3775P AD=0.18625P PS=2.51U
+ PD=1.245U
M$114 A6 Sh1b \$146 GND nfet_03v3 L=0.28U W=0.5U AS=0.18625P AD=0.2625P
+ PS=1.245U PD=2.05U
M$115 \$147 Sh2 \$146 GND nfet_03v3 L=0.28U W=0.5U AS=0.355P AD=0.18625P
+ PS=2.42U PD=1.245U
M$116 \$157 Sh2b \$147 GND nfet_03v3 L=0.28U W=0.5U AS=0.18625P AD=0.2625P
+ PS=1.245U PD=2.05U
M$117 \$30 Sh4 \$147 GND nfet_03v3 L=0.28U W=0.5U AS=0.3575P AD=0.18625P
+ PS=2.43U PD=1.245U
M$118 \$158 Sh4b \$30 GND nfet_03v3 L=0.28U W=0.5U AS=0.18625P AD=0.27P
+ PS=1.245U PD=2.08U
M$119 \$150 Sh8 \$30 GND nfet_03v3 L=0.28U W=0.5U AS=0.3575P AD=0.18625P
+ PS=2.43U PD=1.245U
M$120 GND Sh8b \$150 GND nfet_03v3 L=0.28U W=0.5U AS=0.18625P AD=0.27P
+ PS=1.245U PD=2.08U
M$121 \$151 \$150 GND GND nfet_03v3 L=0.28U W=0.5U AS=0.325P AD=0.2875P PS=2.3U
+ PD=2.15U
M$122 OUT7 \$151 GND GND nfet_03v3 L=0.28U W=0.5U AS=0.2975P AD=0.315P PS=2.19U
+ PD=2.26U
M$123 \$161 \$167 GND GND nfet_03v3 L=0.28U W=0.5U AS=0.325P AD=0.2875P PS=2.3U
+ PD=2.15U
M$124 OUT6 \$161 GND GND nfet_03v3 L=0.28U W=0.5U AS=0.2975P AD=0.315P PS=2.19U
+ PD=2.26U
M$125 \$136 Sh1 A6 GND nfet_03v3 L=0.28U W=0.5U AS=0.3775P AD=0.18625P PS=2.51U
+ PD=1.245U
M$126 A5 Sh1b \$136 GND nfet_03v3 L=0.28U W=0.5U AS=0.18625P AD=0.2625P
+ PS=1.245U PD=2.05U
M$127 \$107 Sh2 \$136 GND nfet_03v3 L=0.28U W=0.5U AS=0.3775P AD=0.18625P
+ PS=2.51U PD=1.245U
M$128 \$170 Sh2b \$107 GND nfet_03v3 L=0.28U W=0.5U AS=0.18625P AD=0.2625P
+ PS=1.245U PD=2.05U
M$129 \$45 Sh4 \$107 GND nfet_03v3 L=0.28U W=0.5U AS=0.3775P AD=0.18625P
+ PS=2.51U PD=1.245U
M$130 \$200 Sh4b \$45 GND nfet_03v3 L=0.28U W=0.5U AS=0.18625P AD=0.2625P
+ PS=1.245U PD=2.05U
M$131 \$167 Sh8 \$45 GND nfet_03v3 L=0.28U W=0.5U AS=0.3775P AD=0.18625P
+ PS=2.51U PD=1.245U
M$132 GND Sh8b \$167 GND nfet_03v3 L=0.28U W=0.5U AS=0.18625P AD=0.2625P
+ PS=1.245U PD=2.05U
M$133 \$157 Sh1 A5 GND nfet_03v3 L=0.28U W=0.5U AS=0.3775P AD=0.18625P PS=2.51U
+ PD=1.245U
M$134 A4 Sh1b \$157 GND nfet_03v3 L=0.28U W=0.5U AS=0.18625P AD=0.2625P
+ PS=1.245U PD=2.05U
M$135 \$122 Sh2 \$157 GND nfet_03v3 L=0.28U W=0.5U AS=0.355P AD=0.18625P
+ PS=2.42U PD=1.245U
M$136 \$198 Sh2b \$122 GND nfet_03v3 L=0.28U W=0.5U AS=0.18625P AD=0.2625P
+ PS=1.245U PD=2.05U
M$137 \$148 Sh4 \$122 GND nfet_03v3 L=0.28U W=0.5U AS=0.3575P AD=0.18625P
+ PS=2.43U PD=1.245U
M$138 \$185 Sh4b \$148 GND nfet_03v3 L=0.28U W=0.5U AS=0.18625P AD=0.27P
+ PS=1.245U PD=2.08U
M$139 \$178 Sh8 \$148 GND nfet_03v3 L=0.28U W=0.5U AS=0.3575P AD=0.18625P
+ PS=2.43U PD=1.245U
M$140 GND Sh8b \$178 GND nfet_03v3 L=0.28U W=0.5U AS=0.18625P AD=0.27P
+ PS=1.245U PD=2.08U
M$141 \$179 \$178 GND GND nfet_03v3 L=0.28U W=0.5U AS=0.325P AD=0.2875P PS=2.3U
+ PD=2.15U
M$142 OUT5 \$179 GND GND nfet_03v3 L=0.28U W=0.5U AS=0.2975P AD=0.315P PS=2.19U
+ PD=2.26U
M$143 \$193 \$192 GND GND nfet_03v3 L=0.28U W=0.5U AS=0.325P AD=0.2875P PS=2.3U
+ PD=2.15U
M$144 OUT4 \$193 GND GND nfet_03v3 L=0.28U W=0.5U AS=0.2975P AD=0.315P PS=2.19U
+ PD=2.26U
M$145 \$170 Sh1 A4 GND nfet_03v3 L=0.28U W=0.5U AS=0.3775P AD=0.18625P PS=2.51U
+ PD=1.245U
M$146 A3 Sh1b \$170 GND nfet_03v3 L=0.28U W=0.5U AS=0.18625P AD=0.2625P
+ PS=1.245U PD=2.05U
M$147 \$138 Sh2 \$170 GND nfet_03v3 L=0.28U W=0.5U AS=0.3775P AD=0.18625P
+ PS=2.51U PD=1.245U
M$148 \$199 Sh2b \$138 GND nfet_03v3 L=0.28U W=0.5U AS=0.18625P AD=0.2625P
+ PS=1.245U PD=2.05U
M$149 \$77 Sh4 \$138 GND nfet_03v3 L=0.28U W=0.5U AS=0.3775P AD=0.18625P
+ PS=2.51U PD=1.245U
M$150 \$201 Sh4b \$77 GND nfet_03v3 L=0.28U W=0.5U AS=0.18625P AD=0.2625P
+ PS=1.245U PD=2.05U
M$151 \$192 Sh8 \$77 GND nfet_03v3 L=0.28U W=0.5U AS=0.3775P AD=0.18625P
+ PS=2.51U PD=1.245U
M$152 GND Sh8b \$192 GND nfet_03v3 L=0.28U W=0.5U AS=0.18625P AD=0.2625P
+ PS=1.245U PD=2.05U
M$153 \$198 Sh1 A3 GND nfet_03v3 L=0.28U W=0.5U AS=0.3775P AD=0.18625P PS=2.51U
+ PD=1.245U
M$154 A2 Sh1b \$198 GND nfet_03v3 L=0.28U W=0.5U AS=0.18625P AD=0.2625P
+ PS=1.245U PD=2.05U
M$155 \$158 Sh2 \$198 GND nfet_03v3 L=0.28U W=0.5U AS=0.355P AD=0.18625P
+ PS=2.42U PD=1.245U
M$156 \$215 Sh2b \$158 GND nfet_03v3 L=0.28U W=0.5U AS=0.18625P AD=0.2625P
+ PS=1.245U PD=2.05U
M$157 \$90 Sh4 \$158 GND nfet_03v3 L=0.28U W=0.5U AS=0.3575P AD=0.18625P
+ PS=2.43U PD=1.245U
M$158 GND Sh4b \$90 GND nfet_03v3 L=0.28U W=0.5U AS=0.18625P AD=0.27P PS=1.245U
+ PD=2.08U
M$159 \$208 Sh8 \$90 GND nfet_03v3 L=0.28U W=0.5U AS=0.3575P AD=0.18625P
+ PS=2.43U PD=1.245U
M$160 GND Sh8b \$208 GND nfet_03v3 L=0.28U W=0.5U AS=0.18625P AD=0.27P
+ PS=1.245U PD=2.08U
M$161 \$209 \$208 GND GND nfet_03v3 L=0.28U W=0.5U AS=0.325P AD=0.2875P PS=2.3U
+ PD=2.15U
M$162 OUT3 \$209 GND GND nfet_03v3 L=0.28U W=0.5U AS=0.2975P AD=0.315P PS=2.19U
+ PD=2.26U
M$163 \$216 \$224 GND GND nfet_03v3 L=0.28U W=0.5U AS=0.325P AD=0.2875P PS=2.3U
+ PD=2.15U
M$164 OUT2 \$216 GND GND nfet_03v3 L=0.28U W=0.5U AS=0.2975P AD=0.315P PS=2.19U
+ PD=2.26U
M$165 \$199 Sh1 A2 GND nfet_03v3 L=0.28U W=0.5U AS=0.3775P AD=0.18625P PS=2.51U
+ PD=1.245U
M$166 A1 Sh1b \$199 GND nfet_03v3 L=0.28U W=0.5U AS=0.18625P AD=0.2625P
+ PS=1.245U PD=2.05U
M$167 \$200 Sh2 \$199 GND nfet_03v3 L=0.28U W=0.5U AS=0.3775P AD=0.18625P
+ PS=2.51U PD=1.245U
M$168 \$228 Sh2b \$200 GND nfet_03v3 L=0.28U W=0.5U AS=0.18625P AD=0.2625P
+ PS=1.245U PD=2.05U
M$169 \$149 Sh4 \$200 GND nfet_03v3 L=0.28U W=0.5U AS=0.3775P AD=0.18625P
+ PS=2.51U PD=1.245U
M$170 GND Sh4b \$149 GND nfet_03v3 L=0.28U W=0.5U AS=0.18625P AD=0.2625P
+ PS=1.245U PD=2.05U
M$171 \$224 Sh8 \$149 GND nfet_03v3 L=0.28U W=0.5U AS=0.3775P AD=0.18625P
+ PS=2.51U PD=1.245U
M$172 GND Sh8b \$224 GND nfet_03v3 L=0.28U W=0.5U AS=0.18625P AD=0.2625P
+ PS=1.245U PD=2.05U
M$173 \$215 Sh1 A1 GND nfet_03v3 L=0.28U W=0.5U AS=0.3775P AD=0.18625P PS=2.51U
+ PD=1.245U
M$174 A0 Sh1b \$215 GND nfet_03v3 L=0.28U W=0.5U AS=0.18625P AD=0.2625P
+ PS=1.245U PD=2.05U
M$175 \$185 Sh2 \$215 GND nfet_03v3 L=0.28U W=0.5U AS=0.355P AD=0.18625P
+ PS=2.42U PD=1.245U
M$176 GND Sh2b \$185 GND nfet_03v3 L=0.28U W=0.5U AS=0.18625P AD=0.2625P
+ PS=1.245U PD=2.05U
M$177 \$123 Sh4 \$185 GND nfet_03v3 L=0.28U W=0.5U AS=0.3575P AD=0.18625P
+ PS=2.43U PD=1.245U
M$178 GND Sh4b \$123 GND nfet_03v3 L=0.28U W=0.5U AS=0.18625P AD=0.27P
+ PS=1.245U PD=2.08U
M$179 \$239 Sh8 \$123 GND nfet_03v3 L=0.28U W=0.5U AS=0.3575P AD=0.18625P
+ PS=2.43U PD=1.245U
M$180 GND Sh8b \$239 GND nfet_03v3 L=0.28U W=0.5U AS=0.18625P AD=0.27P
+ PS=1.245U PD=2.08U
M$181 \$235 \$239 GND GND nfet_03v3 L=0.28U W=0.5U AS=0.325P AD=0.2875P PS=2.3U
+ PD=2.15U
M$182 OUT1 \$235 GND GND nfet_03v3 L=0.28U W=0.5U AS=0.2975P AD=0.315P PS=2.19U
+ PD=2.26U
M$183 \$248 \$252 GND GND nfet_03v3 L=0.28U W=0.5U AS=0.325P AD=0.2875P PS=2.3U
+ PD=2.15U
M$184 OUT0 \$248 GND GND nfet_03v3 L=0.28U W=0.5U AS=0.2975P AD=0.315P PS=2.19U
+ PD=2.26U
M$185 \$228 Sh1 A0 GND nfet_03v3 L=0.28U W=0.5U AS=0.3775P AD=0.18625P PS=2.51U
+ PD=1.245U
M$186 GND Sh1b \$228 GND nfet_03v3 L=0.28U W=0.5U AS=0.18625P AD=0.2625P
+ PS=1.245U PD=2.05U
M$187 \$201 Sh2 \$228 GND nfet_03v3 L=0.28U W=0.5U AS=0.3775P AD=0.18625P
+ PS=2.51U PD=1.245U
M$188 GND Sh2b \$201 GND nfet_03v3 L=0.28U W=0.5U AS=0.18625P AD=0.2625P
+ PS=1.245U PD=2.05U
M$189 \$139 Sh4 \$201 GND nfet_03v3 L=0.28U W=0.5U AS=0.3775P AD=0.18625P
+ PS=2.51U PD=1.245U
M$190 GND Sh4b \$139 GND nfet_03v3 L=0.28U W=0.5U AS=0.18625P AD=0.2625P
+ PS=1.245U PD=2.05U
M$191 \$252 Sh8 \$139 GND nfet_03v3 L=0.28U W=0.5U AS=0.3775P AD=0.18625P
+ PS=2.51U PD=1.245U
M$192 GND Sh8b \$252 GND nfet_03v3 L=0.28U W=0.5U AS=0.18625P AD=0.2625P
+ PS=1.245U PD=2.05U
.ENDS SHIFT
