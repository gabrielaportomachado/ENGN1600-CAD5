* Extracted by KLayout with GF180MCU LVS runset on : 06/04/2026 00:37

.SUBCKT SHIFT A15 GND Sh1 Sh2 Sh4 Sh8 Sh1b A14 Sh2b Sh4b Sh8b OUT15 A13 OUT14
+ OUT13 A12 OUT12 A11 A10 OUT11 OUT10 A9 OUT9 A8 A7 OUT8 A6 OUT7 A5 OUT6 A4
+ OUT5 OUT4 A3 OUT3 A2 OUT2 A1 OUT1 A0 OUT0
M$1 \$3 Sh1 A15 GND nfet_03v3 L=0.28U W=0.5U AS=0.3775P AD=0.18625P PS=2.51U
+ PD=1.245U
M$2 A14 Sh1b \$3 GND nfet_03v3 L=0.28U W=0.5U AS=0.18625P AD=0.2625P PS=1.245U
+ PD=2.05U
M$3 \$4 Sh2 \$3 GND nfet_03v3 L=0.28U W=0.5U AS=0.355P AD=0.18625P PS=2.42U
+ PD=1.245U
M$4 \$17 Sh2b \$4 GND nfet_03v3 L=0.28U W=0.5U AS=0.18625P AD=0.2625P PS=1.245U
+ PD=2.05U
M$5 \$8 Sh4 \$4 GND nfet_03v3 L=0.28U W=0.5U AS=0.3575P AD=0.18625P PS=2.43U
+ PD=1.245U
M$6 \$19 Sh4b \$8 GND nfet_03v3 L=0.28U W=0.5U AS=0.18625P AD=0.27P PS=1.245U
+ PD=2.08U
M$7 OUT15 Sh8 \$8 GND nfet_03v3 L=0.28U W=0.5U AS=0.3575P AD=0.18625P PS=2.43U
+ PD=1.245U
M$8 \$93 Sh8b OUT15 GND nfet_03v3 L=0.28U W=0.5U AS=0.18625P AD=0.27P PS=1.245U
+ PD=2.08U
M$9 \$27 Sh1 A14 GND nfet_03v3 L=0.28U W=0.5U AS=0.3775P AD=0.18625P PS=2.51U
+ PD=1.245U
M$10 A13 Sh1b \$27 GND nfet_03v3 L=0.28U W=0.5U AS=0.18625P AD=0.2625P
+ PS=1.245U PD=2.05U
M$11 \$28 Sh2 \$27 GND nfet_03v3 L=0.28U W=0.5U AS=0.3775P AD=0.18625P PS=2.51U
+ PD=1.245U
M$12 \$46 Sh2b \$28 GND nfet_03v3 L=0.28U W=0.5U AS=0.18625P AD=0.2625P
+ PS=1.245U PD=2.05U
M$13 \$29 Sh4 \$28 GND nfet_03v3 L=0.28U W=0.5U AS=0.3775P AD=0.18625P PS=2.51U
+ PD=1.245U
M$14 \$31 Sh4b \$29 GND nfet_03v3 L=0.28U W=0.5U AS=0.18625P AD=0.2625P
+ PS=1.245U PD=2.05U
M$15 OUT14 Sh8 \$29 GND nfet_03v3 L=0.28U W=0.5U AS=0.3775P AD=0.18625P
+ PS=2.51U PD=1.245U
M$16 \$102 Sh8b OUT14 GND nfet_03v3 L=0.28U W=0.5U AS=0.18625P AD=0.2625P
+ PS=1.245U PD=2.05U
M$17 \$17 Sh1 A13 GND nfet_03v3 L=0.28U W=0.5U AS=0.3775P AD=0.18625P PS=2.51U
+ PD=1.245U
M$18 A12 Sh1b \$17 GND nfet_03v3 L=0.28U W=0.5U AS=0.18625P AD=0.2625P
+ PS=1.245U PD=2.05U
M$19 \$37 Sh2 \$17 GND nfet_03v3 L=0.28U W=0.5U AS=0.355P AD=0.18625P PS=2.42U
+ PD=1.245U
M$20 \$38 Sh2b \$37 GND nfet_03v3 L=0.28U W=0.5U AS=0.18625P AD=0.2625P
+ PS=1.245U PD=2.05U
M$21 \$9 Sh4 \$37 GND nfet_03v3 L=0.28U W=0.5U AS=0.3575P AD=0.18625P PS=2.43U
+ PD=1.245U
M$22 \$39 Sh4b \$9 GND nfet_03v3 L=0.28U W=0.5U AS=0.18625P AD=0.27P PS=1.245U
+ PD=2.08U
M$23 OUT13 Sh8 \$9 GND nfet_03v3 L=0.28U W=0.5U AS=0.3575P AD=0.18625P PS=2.43U
+ PD=1.245U
M$24 \$89 Sh8b OUT13 GND nfet_03v3 L=0.28U W=0.5U AS=0.18625P AD=0.27P
+ PS=1.245U PD=2.08U
M$25 \$46 Sh1 A12 GND nfet_03v3 L=0.28U W=0.5U AS=0.3775P AD=0.18625P PS=2.51U
+ PD=1.245U
M$26 A11 Sh1b \$46 GND nfet_03v3 L=0.28U W=0.5U AS=0.18625P AD=0.2625P
+ PS=1.245U PD=2.05U
M$27 \$47 Sh2 \$46 GND nfet_03v3 L=0.28U W=0.5U AS=0.3775P AD=0.18625P PS=2.51U
+ PD=1.245U
M$28 \$51 Sh2b \$47 GND nfet_03v3 L=0.28U W=0.5U AS=0.18625P AD=0.2625P
+ PS=1.245U PD=2.05U
M$29 \$48 Sh4 \$47 GND nfet_03v3 L=0.28U W=0.5U AS=0.3775P AD=0.18625P PS=2.51U
+ PD=1.245U
M$30 \$52 Sh4b \$48 GND nfet_03v3 L=0.28U W=0.5U AS=0.18625P AD=0.2625P
+ PS=1.245U PD=2.05U
M$31 OUT12 Sh8 \$48 GND nfet_03v3 L=0.28U W=0.5U AS=0.3775P AD=0.18625P
+ PS=2.51U PD=1.245U
M$32 \$120 Sh8b OUT12 GND nfet_03v3 L=0.28U W=0.5U AS=0.18625P AD=0.2625P
+ PS=1.245U PD=2.05U
M$33 \$38 Sh1 A11 GND nfet_03v3 L=0.28U W=0.5U AS=0.3775P AD=0.18625P PS=2.51U
+ PD=1.245U
M$34 A10 Sh1b \$38 GND nfet_03v3 L=0.28U W=0.5U AS=0.18625P AD=0.2625P
+ PS=1.245U PD=2.05U
M$35 \$19 Sh2 \$38 GND nfet_03v3 L=0.28U W=0.5U AS=0.355P AD=0.18625P PS=2.42U
+ PD=1.245U
M$36 \$58 Sh2b \$19 GND nfet_03v3 L=0.28U W=0.5U AS=0.18625P AD=0.2625P
+ PS=1.245U PD=2.05U
M$37 \$10 Sh4 \$19 GND nfet_03v3 L=0.28U W=0.5U AS=0.3575P AD=0.18625P PS=2.43U
+ PD=1.245U
M$38 \$92 Sh4b \$10 GND nfet_03v3 L=0.28U W=0.5U AS=0.18625P AD=0.27P PS=1.245U
+ PD=2.08U
M$39 OUT11 Sh8 \$10 GND nfet_03v3 L=0.28U W=0.5U AS=0.3575P AD=0.18625P
+ PS=2.43U PD=1.245U
M$40 \$60 Sh8b OUT11 GND nfet_03v3 L=0.28U W=0.5U AS=0.18625P AD=0.27P
+ PS=1.245U PD=2.08U
M$41 \$51 Sh1 A10 GND nfet_03v3 L=0.28U W=0.5U AS=0.3775P AD=0.18625P PS=2.51U
+ PD=1.245U
M$42 A9 Sh1b \$51 GND nfet_03v3 L=0.28U W=0.5U AS=0.18625P AD=0.2625P PS=1.245U
+ PD=2.05U
M$43 \$31 Sh2 \$51 GND nfet_03v3 L=0.28U W=0.5U AS=0.3775P AD=0.18625P PS=2.51U
+ PD=1.245U
M$44 \$67 Sh2b \$31 GND nfet_03v3 L=0.28U W=0.5U AS=0.18625P AD=0.2625P
+ PS=1.245U PD=2.05U
M$45 \$11 Sh4 \$31 GND nfet_03v3 L=0.28U W=0.5U AS=0.3775P AD=0.18625P PS=2.51U
+ PD=1.245U
M$46 \$96 Sh4b \$11 GND nfet_03v3 L=0.28U W=0.5U AS=0.18625P AD=0.2625P
+ PS=1.245U PD=2.05U
M$47 OUT10 Sh8 \$11 GND nfet_03v3 L=0.28U W=0.5U AS=0.3775P AD=0.18625P
+ PS=2.51U PD=1.245U
M$48 \$90 Sh8b OUT10 GND nfet_03v3 L=0.28U W=0.5U AS=0.18625P AD=0.2625P
+ PS=1.245U PD=2.05U
M$49 \$58 Sh1 A9 GND nfet_03v3 L=0.28U W=0.5U AS=0.3775P AD=0.18625P PS=2.51U
+ PD=1.245U
M$50 A8 Sh1b \$58 GND nfet_03v3 L=0.28U W=0.5U AS=0.18625P AD=0.2625P PS=1.245U
+ PD=2.05U
M$51 \$39 Sh2 \$58 GND nfet_03v3 L=0.28U W=0.5U AS=0.355P AD=0.18625P PS=2.42U
+ PD=1.245U
M$52 \$74 Sh2b \$39 GND nfet_03v3 L=0.28U W=0.5U AS=0.18625P AD=0.2625P
+ PS=1.245U PD=2.05U
M$53 \$12 Sh4 \$39 GND nfet_03v3 L=0.28U W=0.5U AS=0.3575P AD=0.18625P PS=2.43U
+ PD=1.245U
M$54 \$75 Sh4b \$12 GND nfet_03v3 L=0.28U W=0.5U AS=0.18625P AD=0.27P PS=1.245U
+ PD=2.08U
M$55 OUT9 Sh8 \$12 GND nfet_03v3 L=0.28U W=0.5U AS=0.3575P AD=0.18625P PS=2.43U
+ PD=1.245U
M$56 \$76 Sh8b OUT9 GND nfet_03v3 L=0.28U W=0.5U AS=0.18625P AD=0.27P PS=1.245U
+ PD=2.08U
M$57 \$67 Sh1 A8 GND nfet_03v3 L=0.28U W=0.5U AS=0.3775P AD=0.18625P PS=2.51U
+ PD=1.245U
M$58 A7 Sh1b \$67 GND nfet_03v3 L=0.28U W=0.5U AS=0.18625P AD=0.2625P PS=1.245U
+ PD=2.05U
M$59 \$52 Sh2 \$67 GND nfet_03v3 L=0.28U W=0.5U AS=0.3775P AD=0.18625P PS=2.51U
+ PD=1.245U
M$60 \$101 Sh2b \$52 GND nfet_03v3 L=0.28U W=0.5U AS=0.18625P AD=0.2625P
+ PS=1.245U PD=2.05U
M$61 \$13 Sh4 \$52 GND nfet_03v3 L=0.28U W=0.5U AS=0.3775P AD=0.18625P PS=2.51U
+ PD=1.245U
M$62 \$82 Sh4b \$13 GND nfet_03v3 L=0.28U W=0.5U AS=0.18625P AD=0.2625P
+ PS=1.245U PD=2.05U
M$63 OUT8 Sh8 \$13 GND nfet_03v3 L=0.28U W=0.5U AS=0.3775P AD=0.18625P PS=2.51U
+ PD=1.245U
M$64 \$84 Sh8b OUT8 GND nfet_03v3 L=0.28U W=0.5U AS=0.18625P AD=0.2625P
+ PS=1.245U PD=2.05U
M$65 \$74 Sh1 A7 GND nfet_03v3 L=0.28U W=0.5U AS=0.3775P AD=0.18625P PS=2.51U
+ PD=1.245U
M$66 A6 Sh1b \$74 GND nfet_03v3 L=0.28U W=0.5U AS=0.18625P AD=0.2625P PS=1.245U
+ PD=2.05U
M$67 \$92 Sh2 \$74 GND nfet_03v3 L=0.28U W=0.5U AS=0.355P AD=0.18625P PS=2.42U
+ PD=1.245U
M$68 \$104 Sh2b \$92 GND nfet_03v3 L=0.28U W=0.5U AS=0.18625P AD=0.2625P
+ PS=1.245U PD=2.05U
M$69 \$93 Sh4 \$92 GND nfet_03v3 L=0.28U W=0.5U AS=0.3575P AD=0.18625P PS=2.43U
+ PD=1.245U
M$70 \$94 Sh4b \$93 GND nfet_03v3 L=0.28U W=0.5U AS=0.18625P AD=0.27P PS=1.245U
+ PD=2.08U
M$71 OUT7 Sh8 \$93 GND nfet_03v3 L=0.28U W=0.5U AS=0.3575P AD=0.18625P PS=2.43U
+ PD=1.245U
M$72 GND Sh8b OUT7 GND nfet_03v3 L=0.28U W=0.5U AS=0.18625P AD=0.27P PS=1.245U
+ PD=2.08U
M$73 \$101 Sh1 A6 GND nfet_03v3 L=0.28U W=0.5U AS=0.3775P AD=0.18625P PS=2.51U
+ PD=1.245U
M$74 A5 Sh1b \$101 GND nfet_03v3 L=0.28U W=0.5U AS=0.18625P AD=0.2625P
+ PS=1.245U PD=2.05U
M$75 \$96 Sh2 \$101 GND nfet_03v3 L=0.28U W=0.5U AS=0.3775P AD=0.18625P
+ PS=2.51U PD=1.245U
M$76 \$105 Sh2b \$96 GND nfet_03v3 L=0.28U W=0.5U AS=0.18625P AD=0.2625P
+ PS=1.245U PD=2.05U
M$77 \$102 Sh4 \$96 GND nfet_03v3 L=0.28U W=0.5U AS=0.3775P AD=0.18625P
+ PS=2.51U PD=1.245U
M$78 \$106 Sh4b \$102 GND nfet_03v3 L=0.28U W=0.5U AS=0.18625P AD=0.2625P
+ PS=1.245U PD=2.05U
M$79 OUT6 Sh8 \$102 GND nfet_03v3 L=0.28U W=0.5U AS=0.3775P AD=0.18625P
+ PS=2.51U PD=1.245U
M$80 GND Sh8b OUT6 GND nfet_03v3 L=0.28U W=0.5U AS=0.18625P AD=0.2625P
+ PS=1.245U PD=2.05U
M$81 \$104 Sh1 A5 GND nfet_03v3 L=0.28U W=0.5U AS=0.3775P AD=0.18625P PS=2.51U
+ PD=1.245U
M$82 A4 Sh1b \$104 GND nfet_03v3 L=0.28U W=0.5U AS=0.18625P AD=0.2625P
+ PS=1.245U PD=2.05U
M$83 \$75 Sh2 \$104 GND nfet_03v3 L=0.28U W=0.5U AS=0.355P AD=0.18625P PS=2.42U
+ PD=1.245U
M$84 \$113 Sh2b \$75 GND nfet_03v3 L=0.28U W=0.5U AS=0.18625P AD=0.2625P
+ PS=1.245U PD=2.05U
M$85 \$89 Sh4 \$75 GND nfet_03v3 L=0.28U W=0.5U AS=0.3575P AD=0.18625P PS=2.43U
+ PD=1.245U
M$86 \$114 Sh4b \$89 GND nfet_03v3 L=0.28U W=0.5U AS=0.18625P AD=0.27P
+ PS=1.245U PD=2.08U
M$87 OUT5 Sh8 \$89 GND nfet_03v3 L=0.28U W=0.5U AS=0.3575P AD=0.18625P PS=2.43U
+ PD=1.245U
M$88 GND Sh8b OUT5 GND nfet_03v3 L=0.28U W=0.5U AS=0.18625P AD=0.27P PS=1.245U
+ PD=2.08U
M$89 \$105 Sh1 A4 GND nfet_03v3 L=0.28U W=0.5U AS=0.3775P AD=0.18625P PS=2.51U
+ PD=1.245U
M$90 A3 Sh1b \$105 GND nfet_03v3 L=0.28U W=0.5U AS=0.18625P AD=0.2625P
+ PS=1.245U PD=2.05U
M$91 \$82 Sh2 \$105 GND nfet_03v3 L=0.28U W=0.5U AS=0.3775P AD=0.18625P
+ PS=2.51U PD=1.245U
M$92 \$121 Sh2b \$82 GND nfet_03v3 L=0.28U W=0.5U AS=0.18625P AD=0.2625P
+ PS=1.245U PD=2.05U
M$93 \$120 Sh4 \$82 GND nfet_03v3 L=0.28U W=0.5U AS=0.3775P AD=0.18625P
+ PS=2.51U PD=1.245U
M$94 \$122 Sh4b \$120 GND nfet_03v3 L=0.28U W=0.5U AS=0.18625P AD=0.2625P
+ PS=1.245U PD=2.05U
M$95 OUT4 Sh8 \$120 GND nfet_03v3 L=0.28U W=0.5U AS=0.3775P AD=0.18625P
+ PS=2.51U PD=1.245U
M$96 GND Sh8b OUT4 GND nfet_03v3 L=0.28U W=0.5U AS=0.18625P AD=0.2625P
+ PS=1.245U PD=2.05U
M$97 \$113 Sh1 A3 GND nfet_03v3 L=0.28U W=0.5U AS=0.3775P AD=0.18625P PS=2.51U
+ PD=1.245U
M$98 A2 Sh1b \$113 GND nfet_03v3 L=0.28U W=0.5U AS=0.18625P AD=0.2625P
+ PS=1.245U PD=2.05U
M$99 \$94 Sh2 \$113 GND nfet_03v3 L=0.28U W=0.5U AS=0.355P AD=0.18625P PS=2.42U
+ PD=1.245U
M$100 \$131 Sh2b \$94 GND nfet_03v3 L=0.28U W=0.5U AS=0.18625P AD=0.2625P
+ PS=1.245U PD=2.05U
M$101 \$60 Sh4 \$94 GND nfet_03v3 L=0.28U W=0.5U AS=0.3575P AD=0.18625P
+ PS=2.43U PD=1.245U
M$102 GND Sh4b \$60 GND nfet_03v3 L=0.28U W=0.5U AS=0.18625P AD=0.27P PS=1.245U
+ PD=2.08U
M$103 OUT3 Sh8 \$60 GND nfet_03v3 L=0.28U W=0.5U AS=0.3575P AD=0.18625P
+ PS=2.43U PD=1.245U
M$104 GND Sh8b OUT3 GND nfet_03v3 L=0.28U W=0.5U AS=0.18625P AD=0.27P PS=1.245U
+ PD=2.08U
M$105 \$121 Sh1 A2 GND nfet_03v3 L=0.28U W=0.5U AS=0.3775P AD=0.18625P PS=2.51U
+ PD=1.245U
M$106 A1 Sh1b \$121 GND nfet_03v3 L=0.28U W=0.5U AS=0.18625P AD=0.2625P
+ PS=1.245U PD=2.05U
M$107 \$106 Sh2 \$121 GND nfet_03v3 L=0.28U W=0.5U AS=0.3775P AD=0.18625P
+ PS=2.51U PD=1.245U
M$108 \$138 Sh2b \$106 GND nfet_03v3 L=0.28U W=0.5U AS=0.18625P AD=0.2625P
+ PS=1.245U PD=2.05U
M$109 \$90 Sh4 \$106 GND nfet_03v3 L=0.28U W=0.5U AS=0.3775P AD=0.18625P
+ PS=2.51U PD=1.245U
M$110 GND Sh4b \$90 GND nfet_03v3 L=0.28U W=0.5U AS=0.18625P AD=0.2625P
+ PS=1.245U PD=2.05U
M$111 OUT2 Sh8 \$90 GND nfet_03v3 L=0.28U W=0.5U AS=0.3775P AD=0.18625P
+ PS=2.51U PD=1.245U
M$112 GND Sh8b OUT2 GND nfet_03v3 L=0.28U W=0.5U AS=0.18625P AD=0.2625P
+ PS=1.245U PD=2.05U
M$113 \$131 Sh1 A1 GND nfet_03v3 L=0.28U W=0.5U AS=0.3775P AD=0.18625P PS=2.51U
+ PD=1.245U
M$114 A0 Sh1b \$131 GND nfet_03v3 L=0.28U W=0.5U AS=0.18625P AD=0.2625P
+ PS=1.245U PD=2.05U
M$115 \$114 Sh2 \$131 GND nfet_03v3 L=0.28U W=0.5U AS=0.355P AD=0.18625P
+ PS=2.42U PD=1.245U
M$116 GND Sh2b \$114 GND nfet_03v3 L=0.28U W=0.5U AS=0.18625P AD=0.2625P
+ PS=1.245U PD=2.05U
M$117 \$76 Sh4 \$114 GND nfet_03v3 L=0.28U W=0.5U AS=0.3575P AD=0.18625P
+ PS=2.43U PD=1.245U
M$118 GND Sh4b \$76 GND nfet_03v3 L=0.28U W=0.5U AS=0.18625P AD=0.27P PS=1.245U
+ PD=2.08U
M$119 OUT1 Sh8 \$76 GND nfet_03v3 L=0.28U W=0.5U AS=0.3575P AD=0.18625P
+ PS=2.43U PD=1.245U
M$120 GND Sh8b OUT1 GND nfet_03v3 L=0.28U W=0.5U AS=0.18625P AD=0.27P PS=1.245U
+ PD=2.08U
M$121 \$138 Sh1 A0 GND nfet_03v3 L=0.28U W=0.5U AS=0.3775P AD=0.18625P PS=2.51U
+ PD=1.245U
M$122 GND Sh1b \$138 GND nfet_03v3 L=0.28U W=0.5U AS=0.18625P AD=0.2625P
+ PS=1.245U PD=2.05U
M$123 \$122 Sh2 \$138 GND nfet_03v3 L=0.28U W=0.5U AS=0.3775P AD=0.18625P
+ PS=2.51U PD=1.245U
M$124 GND Sh2b \$122 GND nfet_03v3 L=0.28U W=0.5U AS=0.18625P AD=0.2625P
+ PS=1.245U PD=2.05U
M$125 \$84 Sh4 \$122 GND nfet_03v3 L=0.28U W=0.5U AS=0.3775P AD=0.18625P
+ PS=2.51U PD=1.245U
M$126 GND Sh4b \$84 GND nfet_03v3 L=0.28U W=0.5U AS=0.18625P AD=0.2625P
+ PS=1.245U PD=2.05U
M$127 OUT0 Sh8 \$84 GND nfet_03v3 L=0.28U W=0.5U AS=0.3775P AD=0.18625P
+ PS=2.51U PD=1.245U
M$128 GND Sh8b OUT0 GND nfet_03v3 L=0.28U W=0.5U AS=0.18625P AD=0.2625P
+ PS=1.245U PD=2.05U
.ENDS SHIFT
