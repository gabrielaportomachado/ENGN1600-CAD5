** sch_path: /foss/designs/BUF.sch
.subckt BUF IN OUT
*.PININFO IN:I OUT:O
M1 net1 IN VDD VDD pfet_03v3 L=0.28u W=1u nf=1 m=1
M2 net1 IN GND GND nfet_03v3 L=0.28u W=0.5u nf=1 m=1
M3 OUT net1 VDD VDD pfet_03v3 L=0.28u W=1u nf=1 m=1
M4 OUT net1 GND GND nfet_03v3 L=0.28u W=0.5u nf=1 m=1
.ends
.GLOBAL VDD
.GLOBAL GND
