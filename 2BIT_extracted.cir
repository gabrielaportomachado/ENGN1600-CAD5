* Extracted by KLayout with GF180MCU LVS runset on : 05/04/2026 23:34

.SUBCKT 2BIT GND Ax\x2d1 OUT1 IN1 Ax OUT0 IN0 Shb Sh
M$1 OUT1 Sh Ax\x2d1 GND nfet_03v3 L=0.28U W=0.5U AS=0.355P AD=0.18625P PS=2.42U
+ PD=1.245U
M$2 IN1 Shb OUT1 GND nfet_03v3 L=0.28U W=0.5U AS=0.18625P AD=0.2625P PS=1.245U
+ PD=2.05U
M$3 OUT0 Sh Ax GND nfet_03v3 L=0.28U W=0.5U AS=0.3775P AD=0.18625P PS=2.51U
+ PD=1.245U
M$4 IN0 Shb OUT0 GND nfet_03v3 L=0.28U W=0.5U AS=0.18625P AD=0.2625P PS=1.245U
+ PD=2.05U
.ENDS 2BIT
