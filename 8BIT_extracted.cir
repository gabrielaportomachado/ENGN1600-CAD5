* Extracted by KLayout with GF180MCU LVS runset on : 05/04/2026 22:21

.SUBCKT 8BIT Ax\x2d7 Ax\x2d6 Ax\x2d5 Ax\x2d4 Ax\x2d3 Ax\x2d2 Ax\x2d1 Ax GND IN7
+ Shb OUT7 Sh IN6 OUT6 IN5 OUT5 OUT4 IN4 IN3 OUT3 IN2 OUT2 IN1 OUT1 OUT0 IN0
M$1 OUT7 Sh Ax\x2d7 GND nfet_03v3 L=0.28U W=0.5U AS=0.3575P AD=0.18625P
+ PS=2.43U PD=1.245U
M$2 IN7 Shb OUT7 GND nfet_03v3 L=0.28U W=0.5U AS=0.18625P AD=0.27P PS=1.245U
+ PD=2.08U
M$3 OUT6 Sh Ax\x2d6 GND nfet_03v3 L=0.28U W=0.5U AS=0.3775P AD=0.18625P
+ PS=2.51U PD=1.245U
M$4 IN6 Shb OUT6 GND nfet_03v3 L=0.28U W=0.5U AS=0.18625P AD=0.2625P PS=1.245U
+ PD=2.05U
M$5 OUT5 Sh Ax\x2d5 GND nfet_03v3 L=0.28U W=0.5U AS=0.3575P AD=0.18625P
+ PS=2.43U PD=1.245U
M$6 IN5 Shb OUT5 GND nfet_03v3 L=0.28U W=0.5U AS=0.18625P AD=0.27P PS=1.245U
+ PD=2.08U
M$7 OUT4 Sh Ax\x2d4 GND nfet_03v3 L=0.28U W=0.5U AS=0.3775P AD=0.18625P
+ PS=2.51U PD=1.245U
M$8 IN4 Shb OUT4 GND nfet_03v3 L=0.28U W=0.5U AS=0.18625P AD=0.2625P PS=1.245U
+ PD=2.05U
M$9 OUT3 Sh Ax\x2d3 GND nfet_03v3 L=0.28U W=0.5U AS=0.3575P AD=0.18625P
+ PS=2.43U PD=1.245U
M$10 IN3 Shb OUT3 GND nfet_03v3 L=0.28U W=0.5U AS=0.18625P AD=0.27P PS=1.245U
+ PD=2.08U
M$11 OUT2 Sh Ax\x2d2 GND nfet_03v3 L=0.28U W=0.5U AS=0.3775P AD=0.18625P
+ PS=2.51U PD=1.245U
M$12 IN2 Shb OUT2 GND nfet_03v3 L=0.28U W=0.5U AS=0.18625P AD=0.2625P PS=1.245U
+ PD=2.05U
M$13 OUT1 Sh Ax\x2d1 GND nfet_03v3 L=0.28U W=0.5U AS=0.3575P AD=0.18625P
+ PS=2.43U PD=1.245U
M$14 IN1 Shb OUT1 GND nfet_03v3 L=0.28U W=0.5U AS=0.18625P AD=0.27P PS=1.245U
+ PD=2.08U
M$15 OUT0 Sh Ax GND nfet_03v3 L=0.28U W=0.5U AS=0.3775P AD=0.18625P PS=2.51U
+ PD=1.245U
M$16 IN0 Shb OUT0 GND nfet_03v3 L=0.28U W=0.5U AS=0.18625P AD=0.2625P PS=1.245U
+ PD=2.05U
.ENDS 8BIT
