* NGSPICE file created from SHIFT.ext - technology: gf180mcuD

.subckt SHIFT OUT1 OUT2 OUT3 OUT4 OUT5 OUT6 OUT7 OUT8 OUT9 OUT10 OUT11 OUT12 OUT0
+ OUT13 OUT14 OUT15 GND A1 A2 A3 A4 A5 A6 A7 A8 A9 A10 A11 A12 A0 A13 A14 A15
X0 m2_n7_n8438# SH1 A12.t1 GND.t0 nfet_03v3 ad=0.18625p pd=1.245u as=0.3775p ps=2.51u w=0.5u l=0.28u
X1 OUT15.t0 SH8 a_2735_n10830# GND.t2 nfet_03v3 ad=0.18625p pd=1.245u as=0.3575p ps=2.43u w=0.5u l=0.28u
X2 a_484_n9954# SH2 m2_n7_n9922# GND.t16 nfet_03v3 ad=0.18625p pd=1.245u as=0.3775p ps=2.51u w=0.5u l=0.28u
X3 GND.t10 SH8B OUT7.t1 GND.t2 nfet_03v3 ad=0.27p pd=2.08u as=0.18625p ps=1.245u w=0.5u l=0.28u
X4 GND.t9 SH8B OUT6.t1 GND.t2 nfet_03v3 ad=0.2625p pd=2.05u as=0.18625p ps=1.245u w=0.5u l=0.28u
X5 A5.t0 SH1B m2_n7_n3986# GND.t0 nfet_03v3 ad=0.2625p pd=2.05u as=0.18625p ps=1.245u w=0.5u l=0.28u
X6 OUT4.t0 SH8 a_2735_n8210.t0 GND.t2 nfet_03v3 ad=0.18625p pd=1.245u as=0.3775p ps=2.51u w=0.5u l=0.28u
X7 a_484_n5502# SH2 m2_n7_n5470# GND.t16 nfet_03v3 ad=0.18625p pd=1.245u as=0.3775p ps=2.51u w=0.5u l=0.28u
X8 OUT7.t0 SH8 a_2735_n4931.t0 GND.t2 nfet_03v3 ad=0.18625p pd=1.245u as=0.3575p ps=2.43u w=0.5u l=0.28u
X9 m2_n7_n1018# SH1 A2.t1 GND.t0 nfet_03v3 ad=0.18625p pd=1.245u as=0.3775p ps=2.51u w=0.5u l=0.28u
X10 a_2735_n7476.t1 SH8B OUT11.t1 GND.t2 nfet_03v3 ad=0.27p pd=2.08u as=0.18625p ps=1.245u w=0.5u l=0.28u
X11 A0.t0 SH1B m2_n7_n276# GND.t0 nfet_03v3 ad=0.2625p pd=2.05u as=0.18625p ps=1.245u w=0.5u l=0.28u
X12 a_484_n7728# SH2 m2_n7_n7696# GND.t16 nfet_03v3 ad=0.18625p pd=1.245u as=0.355p ps=2.42u w=0.5u l=0.28u
X13 m2_n7_n3244# SH1 A5.t1 GND.t0 nfet_03v3 ad=0.18625p pd=1.245u as=0.3775p ps=2.51u w=0.5u l=0.28u
X14 A8.t0 SH1B m2_n7_n6212# GND.t0 nfet_03v3 ad=0.2625p pd=2.05u as=0.18625p ps=1.245u w=0.5u l=0.28u
X15 GND.t15 SH4B a_2735_n7476.t2 GND.t11 nfet_03v3 ad=0.27p pd=2.08u as=0.18625p ps=1.245u w=0.5u l=0.28u
X16 m2_n7_n6954# SH2B a_484_n8470# GND.t16 nfet_03v3 ad=0.2625p pd=2.05u as=0.18625p ps=1.245u w=0.5u l=0.28u
X17 OUT9.t0 SH8 a_2735_n6405.t0 GND.t2 nfet_03v3 ad=0.18625p pd=1.245u as=0.3575p ps=2.43u w=0.5u l=0.28u
X18 OUT8.t0 SH8 a_2735_n5672.t0 GND.t2 nfet_03v3 ad=0.18625p pd=1.245u as=0.3775p ps=2.51u w=0.5u l=0.28u
X19 OUT6.t0 SH8 a_2735_n9685.t0 GND.t2 nfet_03v3 ad=0.18625p pd=1.245u as=0.3775p ps=2.51u w=0.5u l=0.28u
X20 a_484_434# SH4B a_2735_n8210.t2 GND.t11 nfet_03v3 ad=0.2625p pd=2.05u as=0.18625p ps=1.245u w=0.5u l=0.28u
X21 m2_n7_n10664# SH1 A15.t0 GND.t0 nfet_03v3 ad=0.18625p pd=1.245u as=0.3775p ps=2.51u w=0.5u l=0.28u
X22 m2_n7_466# SH1 A0.t1 GND.t0 nfet_03v3 ad=0.18625p pd=1.245u as=0.3775p ps=2.51u w=0.5u l=0.28u
X23 A9.t0 SH1B m2_n7_n6954# GND.t0 nfet_03v3 ad=0.2625p pd=2.05u as=0.18625p ps=1.245u w=0.5u l=0.28u
X24 OUT11.t0 SH8 a_2735_n7880# GND.t2 nfet_03v3 ad=0.18625p pd=1.245u as=0.3575p ps=2.43u w=0.5u l=0.28u
X25 a_2735_n8951.t1 SH8B OUT13.t1 GND.t2 nfet_03v3 ad=0.27p pd=2.08u as=0.18625p ps=1.245u w=0.5u l=0.28u
X26 a_2735_227.t3 SH4 a_484_434# GND.t11 nfet_03v3 ad=0.18625p pd=1.245u as=0.3775p ps=2.51u w=0.5u l=0.28u
X27 m2_n7_n6212# SH1 A9.t1 GND.t0 nfet_03v3 ad=0.18625p pd=1.245u as=0.3775p ps=2.51u w=0.5u l=0.28u
X28 a_484_n1050# SH4B a_2735_n9685.t2 GND.t11 nfet_03v3 ad=0.2625p pd=2.05u as=0.18625p ps=1.245u w=0.5u l=0.28u
X29 a_484_n8470# SH2 m2_n7_n8438# GND.t16 nfet_03v3 ad=0.18625p pd=1.245u as=0.3775p ps=2.51u w=0.5u l=0.28u
X30 OUT1.t0 SH8 a_2735_n506.t0 GND.t2 nfet_03v3 ad=0.18625p pd=1.245u as=0.3575p ps=2.43u w=0.5u l=0.28u
X31 a_2735_n7476.t3 SH4 a_484_n1792# GND.t11 nfet_03v3 ad=0.18625p pd=1.245u as=0.3575p ps=2.43u w=0.5u l=0.28u
X32 m2_n7_n9180# SH2B a_484_n10696# GND.t16 nfet_03v3 ad=0.2625p pd=2.05u as=0.18625p ps=1.245u w=0.5u l=0.28u
X33 GND.t18 SH2B a_484_n308# GND.t16 nfet_03v3 ad=0.2625p pd=2.05u as=0.18625p ps=1.245u w=0.5u l=0.28u
X34 a_484_n7728# SH4B a_2735_n10830# GND.t11 nfet_03v3 ad=0.27p pd=2.08u as=0.18625p ps=1.245u w=0.5u l=0.28u
X35 a_2735_n8210.t3 SH4 a_484_n2534# GND.t11 nfet_03v3 ad=0.18625p pd=1.245u as=0.3775p ps=2.51u w=0.5u l=0.28u
X36 m2_n7_n2502# SH2B a_484_n4018# GND.t16 nfet_03v3 ad=0.2625p pd=2.05u as=0.18625p ps=1.245u w=0.5u l=0.28u
X37 A12.t0 SH1B m2_n7_n9180# GND.t0 nfet_03v3 ad=0.2625p pd=2.05u as=0.18625p ps=1.245u w=0.5u l=0.28u
X38 a_484_n1792# SH4B a_2735_n4931.t2 GND.t11 nfet_03v3 ad=0.27p pd=2.08u as=0.18625p ps=1.245u w=0.5u l=0.28u
X39 a_484_n3276# SH4B a_2735_n6405.t1 GND.t11 nfet_03v3 ad=0.27p pd=2.08u as=0.18625p ps=1.245u w=0.5u l=0.28u
X40 a_484_n2534# SH4B a_2735_n5672.t1 GND.t11 nfet_03v3 ad=0.2625p pd=2.05u as=0.18625p ps=1.245u w=0.5u l=0.28u
X41 a_484_n1050# SH2 m2_n7_n1018# GND.t16 nfet_03v3 ad=0.18625p pd=1.245u as=0.3775p ps=2.51u w=0.5u l=0.28u
X42 A2.t0 SH1B m2_n7_n1760# GND.t0 nfet_03v3 ad=0.2625p pd=2.05u as=0.18625p ps=1.245u w=0.5u l=0.28u
X43 a_2735_n8951.t3 SH4 a_484_n3276# GND.t11 nfet_03v3 ad=0.18625p pd=1.245u as=0.3575p ps=2.43u w=0.5u l=0.28u
X44 A13.t0 SH1B m2_n7_n9922# GND.t0 nfet_03v3 ad=0.2625p pd=2.05u as=0.18625p ps=1.245u w=0.5u l=0.28u
X45 m2_n7_n4728# SH2B a_484_n6244# GND.t16 nfet_03v3 ad=0.2625p pd=2.05u as=0.18625p ps=1.245u w=0.5u l=0.28u
X46 a_2735_n6735.t1 SH8B OUT10.t1 GND.t2 nfet_03v3 ad=0.2625p pd=2.05u as=0.18625p ps=1.245u w=0.5u l=0.28u
X47 a_484_n4760# SH4B a_2735_n7880# GND.t11 nfet_03v3 ad=0.27p pd=2.08u as=0.18625p ps=1.245u w=0.5u l=0.28u
X48 a_484_n4018# SH4B a_2735_n7147.t1 GND.t11 nfet_03v3 ad=0.2625p pd=2.05u as=0.18625p ps=1.245u w=0.5u l=0.28u
X49 a_484_n3276# SH2 m2_n7_n3244# GND.t16 nfet_03v3 ad=0.18625p pd=1.245u as=0.355p ps=2.42u w=0.5u l=0.28u
X50 m2_n7_n9180# SH1 A13.t1 GND.t0 nfet_03v3 ad=0.18625p pd=1.245u as=0.3775p ps=2.51u w=0.5u l=0.28u
X51 GND.t8 SH8B OUT3.t1 GND.t2 nfet_03v3 ad=0.27p pd=2.08u as=0.18625p ps=1.245u w=0.5u l=0.28u
X52 a_2735_n4931.t3 SH4 a_484_n4760# GND.t11 nfet_03v3 ad=0.18625p pd=1.245u as=0.3575p ps=2.43u w=0.5u l=0.28u
X53 GND.t17 SH2B a_484_434# GND.t16 nfet_03v3 ad=0.2625p pd=2.05u as=0.18625p ps=1.245u w=0.5u l=0.28u
X54 a_2735_n5672.t2 SH4 a_484_n5502# GND.t11 nfet_03v3 ad=0.18625p pd=1.245u as=0.3775p ps=2.51u w=0.5u l=0.28u
X55 a_2735_n6405.t2 SH4 a_484_n6244# GND.t11 nfet_03v3 ad=0.18625p pd=1.245u as=0.3575p ps=2.43u w=0.5u l=0.28u
X56 GND.t14 SH4B a_2735_n506.t2 GND.t11 nfet_03v3 ad=0.27p pd=2.08u as=0.18625p ps=1.245u w=0.5u l=0.28u
X57 m2_n7_n5470# SH2B a_484_n6986# GND.t16 nfet_03v3 ad=0.2625p pd=2.05u as=0.18625p ps=1.245u w=0.5u l=0.28u
X58 m2_n7_n1760# SH1 A3.t1 GND.t0 nfet_03v3 ad=0.18625p pd=1.245u as=0.3775p ps=2.51u w=0.5u l=0.28u
X59 OUT0.t0 SH8 a_2735_227.t0 GND.t2 nfet_03v3 ad=0.18625p pd=1.245u as=0.3775p ps=2.51u w=0.5u l=0.28u
X60 GND.t7 SH8B OUT2.t1 GND.t2 nfet_03v3 ad=0.2625p pd=2.05u as=0.18625p ps=1.245u w=0.5u l=0.28u
X61 OUT10.t0 SH8 a_2735_n7147.t0 GND.t2 nfet_03v3 ad=0.18625p pd=1.245u as=0.3775p ps=2.51u w=0.5u l=0.28u
X62 a_484_n6244# SH2 m2_n7_n6212# GND.t16 nfet_03v3 ad=0.18625p pd=1.245u as=0.355p ps=2.42u w=0.5u l=0.28u
X63 a_2735_n8210.t1 SH8B OUT12.t1 GND.t2 nfet_03v3 ad=0.2625p pd=2.05u as=0.18625p ps=1.245u w=0.5u l=0.28u
X64 OUT3.t0 SH8 a_2735_n7476.t0 GND.t2 nfet_03v3 ad=0.18625p pd=1.245u as=0.3575p ps=2.43u w=0.5u l=0.28u
X65 GND.t6 SH8B OUT5.t1 GND.t2 nfet_03v3 ad=0.27p pd=2.08u as=0.18625p ps=1.245u w=0.5u l=0.28u
X66 a_484_n5502# SH4B a_2735_n8622# GND.t11 nfet_03v3 ad=0.2625p pd=2.05u as=0.18625p ps=1.245u w=0.5u l=0.28u
X67 a_484_n6244# SH4B a_2735_n9355# GND.t11 nfet_03v3 ad=0.27p pd=2.08u as=0.18625p ps=1.245u w=0.5u l=0.28u
X68 A1.t0 SH1B m2_n7_n1018# GND.t0 nfet_03v3 ad=0.2625p pd=2.05u as=0.18625p ps=1.245u w=0.5u l=0.28u
X69 A6.t0 SH1B m2_n7_n4728# GND.t0 nfet_03v3 ad=0.2625p pd=2.05u as=0.18625p ps=1.245u w=0.5u l=0.28u
X70 m2_n7_n7696# SH2B a_484_n9212# GND.t16 nfet_03v3 ad=0.2625p pd=2.05u as=0.18625p ps=1.245u w=0.5u l=0.28u
X71 m2_n7_n3986# SH1 A6.t1 GND.t0 nfet_03v3 ad=0.18625p pd=1.245u as=0.3775p ps=2.51u w=0.5u l=0.28u
X72 m2_n7_n276# SH1 A1.t1 GND.t0 nfet_03v3 ad=0.18625p pd=1.245u as=0.3775p ps=2.51u w=0.5u l=0.28u
X73 a_2735_n6735.t3 SH4 a_484_n1050# GND.t11 nfet_03v3 ad=0.18625p pd=1.245u as=0.3775p ps=2.51u w=0.5u l=0.28u
X74 m2_n7_n276# SH2B a_484_n1792# GND.t16 nfet_03v3 ad=0.2625p pd=2.05u as=0.18625p ps=1.245u w=0.5u l=0.28u
X75 A10.t0 SH1B m2_n7_n7696# GND.t0 nfet_03v3 ad=0.2625p pd=2.05u as=0.18625p ps=1.245u w=0.5u l=0.28u
X76 a_2735_n9355# SH4 a_484_n9212# GND.t11 nfet_03v3 ad=0.18625p pd=1.245u as=0.3575p ps=2.43u w=0.5u l=0.28u
X77 a_2735_n8622# SH4 a_484_n8470# GND.t11 nfet_03v3 ad=0.18625p pd=1.245u as=0.3775p ps=2.51u w=0.5u l=0.28u
X78 m2_n7_n8438# SH2B a_484_n9954# GND.t16 nfet_03v3 ad=0.2625p pd=2.05u as=0.18625p ps=1.245u w=0.5u l=0.28u
X79 m2_n7_n4728# SH1 A7.t1 GND.t0 nfet_03v3 ad=0.18625p pd=1.245u as=0.3775p ps=2.51u w=0.5u l=0.28u
X80 a_484_n9212# SH2 m2_n7_n9180# GND.t16 nfet_03v3 ad=0.18625p pd=1.245u as=0.355p ps=2.42u w=0.5u l=0.28u
X81 GND.t1 SH1B m2_n7_466# GND.t0 nfet_03v3 ad=0.2625p pd=2.05u as=0.18625p ps=1.245u w=0.5u l=0.28u
X82 OUT13.t0 SH8 a_2735_n9355# GND.t2 nfet_03v3 ad=0.18625p pd=1.245u as=0.3575p ps=2.43u w=0.5u l=0.28u
X83 m2_n7_466# SH2B a_484_n1050# GND.t16 nfet_03v3 ad=0.2625p pd=2.05u as=0.18625p ps=1.245u w=0.5u l=0.28u
X84 GND.t13 SH4B a_2735_227.t2 GND.t11 nfet_03v3 ad=0.2625p pd=2.05u as=0.18625p ps=1.245u w=0.5u l=0.28u
X85 m2_n7_n9922# SH1 A14.t1 GND.t0 nfet_03v3 ad=0.18625p pd=1.245u as=0.3775p ps=2.51u w=0.5u l=0.28u
X86 a_484_n308# SH2 m2_n7_n276# GND.t16 nfet_03v3 ad=0.18625p pd=1.245u as=0.355p ps=2.42u w=0.5u l=0.28u
X87 a_484_n10696# SH2 m2_n7_n10664# GND.t16 nfet_03v3 ad=0.18625p pd=1.245u as=0.355p ps=2.42u w=0.5u l=0.28u
X88 a_484_n1792# SH2 m2_n7_n1760# GND.t16 nfet_03v3 ad=0.18625p pd=1.245u as=0.355p ps=2.42u w=0.5u l=0.28u
X89 m2_n7_n6954# SH1 A10.t1 GND.t0 nfet_03v3 ad=0.18625p pd=1.245u as=0.3775p ps=2.51u w=0.5u l=0.28u
X90 a_2735_n10830# SH4 a_484_n10696# GND.t11 nfet_03v3 ad=0.18625p pd=1.245u as=0.3575p ps=2.43u w=0.5u l=0.28u
X91 a_2735_n9685.t3 SH4 a_484_n4018# GND.t11 nfet_03v3 ad=0.18625p pd=1.245u as=0.3775p ps=2.51u w=0.5u l=0.28u
X92 A3.t0 SH1B m2_n7_n2502# GND.t0 nfet_03v3 ad=0.2625p pd=2.05u as=0.18625p ps=1.245u w=0.5u l=0.28u
X93 m2_n7_n3244# SH2B a_484_n4760# GND.t16 nfet_03v3 ad=0.2625p pd=2.05u as=0.18625p ps=1.245u w=0.5u l=0.28u
X94 GND.t5 SH8B OUT4.t1 GND.t2 nfet_03v3 ad=0.2625p pd=2.05u as=0.18625p ps=1.245u w=0.5u l=0.28u
X95 a_1337_n9945# SH4 a_484_n9954# GND.t11 nfet_03v3 ad=0.18625p pd=1.245u as=0.3775p ps=2.51u w=0.5u l=0.28u
X96 a_484_n4018# SH2 m2_n7_n3986# GND.t16 nfet_03v3 ad=0.18625p pd=1.245u as=0.3775p ps=2.51u w=0.5u l=0.28u
X97 OUT2.t0 SH8 a_2735_n6735.t0 GND.t2 nfet_03v3 ad=0.18625p pd=1.245u as=0.3775p ps=2.51u w=0.5u l=0.28u
X98 a_484_n6986# SH4B a_1337_n9945# GND.t11 nfet_03v3 ad=0.2625p pd=2.05u as=0.18625p ps=1.245u w=0.5u l=0.28u
X99 a_2735_n7880# SH4 a_484_n7728# GND.t11 nfet_03v3 ad=0.18625p pd=1.245u as=0.3575p ps=2.43u w=0.5u l=0.28u
X100 m2_n7_n2502# SH1 A4.t1 GND.t0 nfet_03v3 ad=0.18625p pd=1.245u as=0.3775p ps=2.51u w=0.5u l=0.28u
X101 m2_n7_n6212# SH2B a_484_n7728# GND.t16 nfet_03v3 ad=0.2625p pd=2.05u as=0.18625p ps=1.245u w=0.5u l=0.28u
X102 a_484_n4760# SH2 m2_n7_n4728# GND.t16 nfet_03v3 ad=0.18625p pd=1.245u as=0.355p ps=2.42u w=0.5u l=0.28u
X103 A4.t0 SH1B m2_n7_n3244# GND.t0 nfet_03v3 ad=0.2625p pd=2.05u as=0.18625p ps=1.245u w=0.5u l=0.28u
X104 a_2735_n9685.t1 SH8B OUT14.t1 GND.t2 nfet_03v3 ad=0.2625p pd=2.05u as=0.18625p ps=1.245u w=0.5u l=0.28u
X105 a_2735_n506.t1 SH8B OUT9.t1 GND.t2 nfet_03v3 ad=0.27p pd=2.08u as=0.18625p ps=1.245u w=0.5u l=0.28u
X106 a_2735_227.t1 SH8B OUT8.t1 GND.t2 nfet_03v3 ad=0.2625p pd=2.05u as=0.18625p ps=1.245u w=0.5u l=0.28u
X107 a_2735_n7147.t2 SH4 a_484_n6986# GND.t11 nfet_03v3 ad=0.18625p pd=1.245u as=0.3775p ps=2.51u w=0.5u l=0.28u
X108 a_2735_n506.t3 SH4 a_484_n308# GND.t11 nfet_03v3 ad=0.18625p pd=1.245u as=0.3575p ps=2.43u w=0.5u l=0.28u
X109 GND.t4 SH8B OUT0.t1 GND.t2 nfet_03v3 ad=0.2625p pd=2.05u as=0.18625p ps=1.245u w=0.5u l=0.28u
X110 A7.t0 SH1B m2_n7_n5470# GND.t0 nfet_03v3 ad=0.2625p pd=2.05u as=0.18625p ps=1.245u w=0.5u l=0.28u
X111 A14.t0 SH1B m2_n7_n10664# GND.t0 nfet_03v3 ad=0.2625p pd=2.05u as=0.18625p ps=1.245u w=0.5u l=0.28u
X112 OUT12.t0 SH8 a_2735_n8622# GND.t2 nfet_03v3 ad=0.18625p pd=1.245u as=0.3775p ps=2.51u w=0.5u l=0.28u
X113 OUT5.t0 SH8 a_2735_n8951.t0 GND.t2 nfet_03v3 ad=0.18625p pd=1.245u as=0.3575p ps=2.43u w=0.5u l=0.28u
X114 a_484_n6986# SH2 m2_n7_n6954# GND.t16 nfet_03v3 ad=0.18625p pd=1.245u as=0.3775p ps=2.51u w=0.5u l=0.28u
X115 GND.t3 SH8B OUT1.t1 GND.t2 nfet_03v3 ad=0.27p pd=2.08u as=0.18625p ps=1.245u w=0.5u l=0.28u
X116 OUT14.t0 SH8 a_1337_n9945# GND.t2 nfet_03v3 ad=0.18625p pd=1.245u as=0.3775p ps=2.51u w=0.5u l=0.28u
X117 m2_n7_n1018# SH2B a_484_n2534# GND.t16 nfet_03v3 ad=0.2625p pd=2.05u as=0.18625p ps=1.245u w=0.5u l=0.28u
X118 m2_n7_n5470# SH1 A8.t1 GND.t0 nfet_03v3 ad=0.18625p pd=1.245u as=0.3775p ps=2.51u w=0.5u l=0.28u
X119 m2_n7_n7696# SH1 A11.t1 GND.t0 nfet_03v3 ad=0.18625p pd=1.245u as=0.3775p ps=2.51u w=0.5u l=0.28u
X120 A11.t0 SH1B m2_n7_n8438# GND.t0 nfet_03v3 ad=0.2625p pd=2.05u as=0.18625p ps=1.245u w=0.5u l=0.28u
X121 a_2735_n4931.t1 SH8B OUT15.t1 GND.t2 nfet_03v3 ad=0.27p pd=2.08u as=0.18625p ps=1.245u w=0.5u l=0.28u
X122 a_484_n308# SH4B a_2735_n8951.t2 GND.t11 nfet_03v3 ad=0.27p pd=2.08u as=0.18625p ps=1.245u w=0.5u l=0.28u
X123 a_484_n2534# SH2 m2_n7_n2502# GND.t16 nfet_03v3 ad=0.18625p pd=1.245u as=0.3775p ps=2.51u w=0.5u l=0.28u
X124 m2_n7_n1760# SH2B a_484_n3276# GND.t16 nfet_03v3 ad=0.2625p pd=2.05u as=0.18625p ps=1.245u w=0.5u l=0.28u
X125 GND.t12 SH4B a_2735_n6735.t2 GND.t11 nfet_03v3 ad=0.2625p pd=2.05u as=0.18625p ps=1.245u w=0.5u l=0.28u
X126 m2_n7_n3986# SH2B a_484_n5502# GND.t16 nfet_03v3 ad=0.2625p pd=2.05u as=0.18625p ps=1.245u w=0.5u l=0.28u
X127 a_484_434# SH2 m2_n7_466# GND.t16 nfet_03v3 ad=0.18625p pd=1.245u as=0.3775p ps=2.51u w=0.5u l=0.28u
R0 A12.n0 A12.t0 28.8939
R1 A12.n0 A12.t1 12.4115
R2 A12 A12.n0 0.017375
R3 GND.n6 GND.t11 379.423
R4 GND.n5 GND.t16 231.463
R5 GND.n4 GND.t0 157.617
R6 GND.n14 GND.t10 17.5102
R7 GND.n13 GND.t9 16.5156
R8 GND.n12 GND.t6 15.5288
R9 GND.n11 GND.t5 14.5341
R10 GND.n10 GND.t8 13.5473
R11 GND GND.t15 13.5304
R12 GND.n18 GND.t12 12.533
R13 GND.n9 GND.t7 12.533
R14 GND.n2 GND.t18 11.5669
R15 GND.n17 GND.t14 11.5658
R16 GND.n8 GND.t3 11.5658
R17 GND.n1 GND.t17 10.5665
R18 GND.n16 GND.t13 10.5665
R19 GND.n7 GND.t4 10.5665
R20 GND.n3 GND.t1 10.4956
R21 GND.n7 GND.n6 4.93648
R22 GND.n4 GND.n0 4.38983
R23 GND.n15 GND.n5 4.38567
R24 GND.t0 GND.n3 4.10278
R25 GND.n16 GND.n15 0.553625
R26 GND.n1 GND.n0 0.553625
R27 GND.n3 GND.n2 0.32944
R28 GND.n15 GND.n14 0.13175
R29 GND.n19 GND.n0 0.129875
R30 GND.t11 GND.n5 0.109008
R31 GND.t16 GND.n4 0.108991
R32 GND.n6 GND.t2 0.108956
R33 GND.n2 GND.n1 0.107375
R34 GND.n17 GND.n16 0.107375
R35 GND.n8 GND.n7 0.107375
R36 GND.n18 GND.n17 0.1055
R37 GND.n14 GND.n13 0.1055
R38 GND.n13 GND.n12 0.1055
R39 GND.n12 GND.n11 0.1055
R40 GND.n11 GND.n10 0.1055
R41 GND.n10 GND.n9 0.1055
R42 GND.n9 GND.n8 0.1055
R43 GND.n19 GND.n18 0.1055
R44 GND GND.n19 0.017375
R45 OUT15 OUT15.n0 6.341
R46 OUT15.n0 OUT15.t1 4.7885
R47 OUT15.n0 OUT15.t0 4.5995
R48 OUT7 OUT7.n0 6.30838
R49 OUT7.n0 OUT7.t1 4.7885
R50 OUT7.n0 OUT7.t0 4.5995
R51 OUT6 OUT6.n0 6.30838
R52 OUT6.n0 OUT6.t1 4.7885
R53 OUT6.n0 OUT6.t0 4.5995
R54 A5.n0 A5.t0 28.8939
R55 A5.n0 A5.t1 12.4115
R56 A5 A5.n0 0.017375
R57 a_2735_n8210.n1 a_2735_n8210.t1 30.6913
R58 a_2735_n8210.t0 a_2735_n8210.n1 17.6776
R59 a_2735_n8210.n1 a_2735_n8210.n0 11.7511
R60 a_2735_n8210.n0 a_2735_n8210.t2 4.7885
R61 a_2735_n8210.n0 a_2735_n8210.t3 4.5995
R62 OUT4 OUT4.n0 6.31288
R63 OUT4.n0 OUT4.t1 4.7885
R64 OUT4.n0 OUT4.t0 4.5995
R65 a_2735_n4931.n1 a_2735_n4931.t1 31.1745
R66 a_2735_n4931.t0 a_2735_n4931.n1 18.1366
R67 a_2735_n4931.n1 a_2735_n4931.n0 11.2921
R68 a_2735_n4931.n0 a_2735_n4931.t2 4.7885
R69 a_2735_n4931.n0 a_2735_n4931.t3 4.5995
R70 A2.n0 A2.t0 28.8939
R71 A2.n0 A2.t1 12.4115
R72 A2 A2.n0 0.017375
R73 OUT11 OUT11.n0 6.32075
R74 OUT11.n0 OUT11.t1 4.7885
R75 OUT11.n0 OUT11.t0 4.5995
R76 a_2735_n7476.n1 a_2735_n7476.t1 30.5303
R77 a_2735_n7476.t0 a_2735_n7476.n1 17.5246
R78 a_2735_n7476.n1 a_2735_n7476.n0 11.9244
R79 a_2735_n7476.n0 a_2735_n7476.t2 4.7885
R80 a_2735_n7476.n0 a_2735_n7476.t3 4.5995
R81 A0.n0 A0.t0 28.8939
R82 A0.n0 A0.t1 12.4115
R83 A0 A0.n0 0.017375
R84 A8.n0 A8.t0 28.8939
R85 A8.n0 A8.t1 12.4115
R86 A8 A8.n0 0.017375
R87 a_2735_n6405.t0 a_2735_n6405.n0 29.4069
R88 a_2735_n6405.n0 a_2735_n6405.t1 4.7885
R89 a_2735_n6405.n0 a_2735_n6405.t2 4.5995
R90 OUT9 OUT9.n0 6.31062
R91 OUT9.n0 OUT9.t1 4.7885
R92 OUT9.n0 OUT9.t0 4.5995
R93 a_2735_n5672.t0 a_2735_n5672.n0 29.4069
R94 a_2735_n5672.n0 a_2735_n5672.t1 4.7885
R95 a_2735_n5672.n0 a_2735_n5672.t2 4.5995
R96 OUT8 OUT8.n0 6.3095
R97 OUT8.n0 OUT8.t1 4.7885
R98 OUT8.n0 OUT8.t0 4.5995
R99 a_2735_n9685.n1 a_2735_n9685.t1 31.0134
R100 a_2735_n9685.t0 a_2735_n9685.n1 17.9836
R101 a_2735_n9685.n1 a_2735_n9685.n0 11.4451
R102 a_2735_n9685.n0 a_2735_n9685.t2 4.7885
R103 a_2735_n9685.n0 a_2735_n9685.t3 4.5995
R104 A15 A15.t0 12.4284
R105 A9.n0 A9.t0 28.8939
R106 A9.n0 A9.t1 12.4115
R107 A9 A9.n0 0.017375
R108 OUT13 OUT13.n0 6.33088
R109 OUT13.n0 OUT13.t1 4.7885
R110 OUT13.n0 OUT13.t0 4.5995
R111 a_2735_n8951.n1 a_2735_n8951.t1 30.8524
R112 a_2735_n8951.t0 a_2735_n8951.n1 17.8306
R113 a_2735_n8951.n1 a_2735_n8951.n0 11.5981
R114 a_2735_n8951.n0 a_2735_n8951.t2 4.7885
R115 a_2735_n8951.n0 a_2735_n8951.t3 4.5995
R116 a_2735_227.n1 a_2735_227.t1 30.0425
R117 a_2735_227.t0 a_2735_227.n1 17.0645
R118 a_2735_227.n1 a_2735_227.n0 12.3845
R119 a_2735_227.n0 a_2735_227.t2 4.7885
R120 a_2735_227.n0 a_2735_227.t3 4.5995
R121 a_2735_n506.n1 a_2735_n506.t1 30.297
R122 a_2735_n506.t0 a_2735_n506.n1 17.2175
R123 a_2735_n506.n1 a_2735_n506.n0 12.2315
R124 a_2735_n506.n0 a_2735_n506.t2 4.7885
R125 a_2735_n506.n0 a_2735_n506.t3 4.5995
R126 OUT1 OUT1.n0 6.332
R127 OUT1.n0 OUT1.t1 4.7885
R128 OUT1.n0 OUT1.t0 4.5995
R129 A13.n0 A13.t0 28.8939
R130 A13.n0 A13.t1 12.4115
R131 A13 A13.n0 0.017375
R132 OUT10 OUT10.n0 6.31963
R133 OUT10.n0 OUT10.t1 4.7885
R134 OUT10.n0 OUT10.t0 4.5995
R135 a_2735_n6735.n1 a_2735_n6735.t1 30.3496
R136 a_2735_n6735.t0 a_2735_n6735.n1 17.3716
R137 a_2735_n6735.n1 a_2735_n6735.n0 12.0774
R138 a_2735_n6735.n0 a_2735_n6735.t2 4.7885
R139 a_2735_n6735.n0 a_2735_n6735.t3 4.5995
R140 a_2735_n7147.t0 a_2735_n7147.n0 29.4069
R141 a_2735_n7147.n0 a_2735_n7147.t1 4.7885
R142 a_2735_n7147.n0 a_2735_n7147.t2 4.5995
R143 OUT3 OUT3.n0 6.32187
R144 OUT3.n0 OUT3.t1 4.7885
R145 OUT3.n0 OUT3.t0 4.5995
R146 A3.n0 A3.t0 28.8939
R147 A3.n0 A3.t1 12.4115
R148 A3 A3.n0 0.017375
R149 OUT0 OUT0.n0 6.33312
R150 OUT0.n0 OUT0.t1 4.7885
R151 OUT0.n0 OUT0.t0 4.5995
R152 OUT2 OUT2.n0 6.323
R153 OUT2.n0 OUT2.t1 4.7885
R154 OUT2.n0 OUT2.t0 4.5995
R155 OUT12 OUT12.n0 6.32975
R156 OUT12.n0 OUT12.t1 4.7885
R157 OUT12.n0 OUT12.t0 4.5995
R158 OUT5 OUT5.n0 6.31175
R159 OUT5.n0 OUT5.t1 4.7885
R160 OUT5.n0 OUT5.t0 4.5995
R161 A1.n0 A1.t0 28.8939
R162 A1.n0 A1.t1 12.4115
R163 A1 A1.n0 0.017375
R164 A6.n0 A6.t0 28.8939
R165 A6.n0 A6.t1 12.4115
R166 A6 A6.n0 0.017375
R167 A10.n0 A10.t0 28.8939
R168 A10.n0 A10.t1 12.4115
R169 A10 A10.n0 0.017375
R170 A7.n0 A7.t0 28.8939
R171 A7.n0 A7.t1 12.4115
R172 A7 A7.n0 0.017375
R173 A14.n0 A14.t0 28.8939
R174 A14.n0 A14.t1 12.4115
R175 A14 A14.n0 0.017375
R176 A4.n0 A4.t0 28.8939
R177 A4.n0 A4.t1 12.4115
R178 A4 A4.n0 0.017375
R179 OUT14 OUT14.n0 6.33988
R180 OUT14.n0 OUT14.t1 4.7885
R181 OUT14.n0 OUT14.t0 4.5995
R182 A11.n0 A11.t0 28.8939
R183 A11.n0 A11.t1 12.4115
R184 A11 A11.n0 0.017375
C0 a_2735_n9355# m2_n7_n10664# 0
C1 OUT13 a_484_n8470# 0
C2 m2_n7_n4728# m2_n7_n3986# 0.45905f
C3 m2_n7_n10664# a_484_n10696# 0.10709f
C4 SH4 a_2735_n8622# 0.02312f
C5 a_484_n4018# SH8 0
C6 m2_n7_n9922# A15 0
C7 a_2735_n7880# a_2735_n9355# 0.04264f
C8 SH4B OUT4 0
C9 a_2735_n7880# SH8 0.00835f
C10 m2_n7_n9922# a_2735_n9355# 0
C11 a_2735_n7880# a_484_n10696# 0
C12 OUT5 OUT4 0.01035f
C13 A3 m2_n7_n2502# 0.04379f
C14 SH1B m2_n7_n9180# 0.0106f
C15 SH8B a_1337_n9945# 0.01788f
C16 A6 m2_n7_n3986# 0.12891f
C17 m2_n7_n9922# a_484_n10696# 0.08366f
C18 a_2735_n7880# OUT15 0.00134f
C19 a_2735_n8622# a_484_n6244# 0.02655f
C20 a_484_n4760# SH8 0
C21 SH2 m2_n7_n8438# 0.0207f
C22 m2_n7_n6954# A11 0
C23 m2_n7_n5470# SH1 0.02035f
C24 m2_n7_n4728# a_484_n2534# 0
C25 a_484_n9212# a_1337_n9945# 0.01215f
C26 m2_n7_n1760# SH1 0.03766f
C27 A14 a_484_n8470# 0
C28 a_484_n9954# SH1B 0
C29 m2_n7_n6954# SH1 0.02035f
C30 m2_n7_n1760# m2_n7_n276# 0.02712f
C31 m2_n7_n1018# a_484_434# 0
C32 SH1B A12 0.05457f
C33 SH2 A4 0
C34 SH4 m2_n7_n8438# 0
C35 a_2735_n8622# a_484_n6986# 0.00224f
C36 SH8B OUT8 0.01034f
C37 A6 a_484_n2534# 0
C38 m2_n7_n4728# a_484_n3276# 0
C39 A2 SH1 0.01558f
C40 m2_n7_n3986# a_484_n5502# 0.03526f
C41 OUT14 a_484_n8470# 0
C42 A2 m2_n7_n276# 0.00301f
C43 m2_n7_n9180# a_484_n8470# 0
C44 SH1B A11 0.05457f
C45 m2_n7_n1018# a_484_n308# 0.00146f
C46 a_2735_n7880# OUT13 0.00134f
C47 a_484_n5502# a_484_n8470# 0.03117f
C48 a_2735_n8622# a_484_n7728# 0.00968f
C49 m2_n7_n8438# a_484_n6244# 0.0024f
C50 SH2B m2_n7_n1018# 0.06873f
C51 m2_n7_n4728# a_484_n4018# 0
C52 A6 a_484_n3276# 0
C53 OUT6 a_484_n2534# 0
C54 SH1 SH1B 1.08645f
C55 A9 SH1 0.01558f
C56 m2_n7_n7696# m2_n7_n6212# 0.02712f
C57 SH8 OUT7 0.01726f
C58 a_484_n9954# a_484_n8470# 0.04848f
C59 m2_n7_n276# SH1B 0.0106f
C60 a_484_n2534# a_484_n5502# 0.03117f
C61 SH4 OUT4 0
C62 m2_n7_n1018# a_484_n1050# 0.19703f
C63 A12 a_484_n8470# 0
C64 SH2B m2_n7_n6212# 0.09596f
C65 A14 m2_n7_n10664# 0.04379f
C66 SH4B m2_n7_n1018# 0
C67 m2_n7_n8438# a_484_n6986# 0.00785f
C68 a_484_n9212# SH8B 0
C69 A6 a_484_n4018# 0
C70 m2_n7_n4728# a_484_n4760# 0.10709f
C71 OUT6 a_484_n3276# 0
C72 A10 m2_n7_n6212# 0.00301f
C73 m2_n7_n3986# SH1 0.02035f
C74 A0 SH1B 0.05491f
C75 SH2B a_1337_n9945# 0
C76 m2_n7_n9922# A13 0.04379f
C77 m2_n7_n4728# m2_n7_n3244# 0.02712f
C78 OUT1 SH8B 0.01034f
C79 a_484_n3276# a_484_n5502# 0.16607f
C80 SH4B m2_n7_n6212# 0
C81 SH2B A8 0
C82 m2_n7_n9922# A14 0.12891f
C83 m2_n7_n8438# a_484_n7728# 0.0105f
C84 m2_n7_n10664# m2_n7_n9180# 0.02547f
C85 SH4B a_1337_n9945# 0.01156f
C86 m2_n7_n4728# A7 0.14389f
C87 a_2735_n7880# OUT14 0.00134f
C88 A6 m2_n7_n3244# 0.00301f
C89 a_484_n4018# a_484_n5502# 0.08718f
C90 SH4B A8 0
C91 a_484_n9954# m2_n7_n10664# 0
C92 a_484_n1792# a_484_434# 0.06976f
C93 a_484_434# SH8B 0
C94 m2_n7_n8438# m2_n7_n6954# 0.03117f
C95 m2_n7_n9922# m2_n7_n9180# 0.20379f
C96 a_2735_n7880# a_484_n5502# 0.04991f
C97 SH2 m2_n7_n1018# 0.02076f
C98 SH8 OUT9 0.01726f
C99 A6 A7 0.04228f
C100 A4 m2_n7_n1760# 0.00301f
C101 a_484_n9954# a_2735_n7880# 0
C102 a_484_n4760# a_484_n5502# 0.12971f
C103 SH4B OUT8 0
C104 a_484_n3276# SH1 0
C105 a_2735_n9355# SH8 0.00835f
C106 a_484_n9954# m2_n7_n9922# 0.19703f
C107 a_2735_n9355# a_484_n10696# 0
C108 A1 a_484_n308# 0
C109 a_484_n1792# a_484_n308# 0.0616f
C110 a_484_n10696# SH8 0
C111 SH2 m2_n7_n6212# 0.01946f
C112 m2_n7_n7696# a_484_n9212# 0.03524f
C113 a_2735_n9355# OUT15 0
C114 SH4 m2_n7_n1018# 0
C115 SH2B a_484_n1792# 0.01057f
C116 OUT15 SH8 0.0166f
C117 m2_n7_n10664# SH1 0.02108f
C118 a_2735_n8622# a_484_n8470# 0.13363f
C119 m2_n7_n8438# SH1B 0.01328f
C120 SH2B a_484_n9212# 0.01289f
C121 SH2 a_1337_n9945# 0
C122 a_2735_n10830# a_1337_n9945# 0.38352f
C123 a_2735_n7880# OUT12 0.00992f
C124 SH4 m2_n7_n6212# 0
C125 a_484_n1792# a_484_n1050# 1.79123f
C126 SH2 A8 0
C127 m2_n7_n2502# SH1 0.02035f
C128 OUT3 SH8 0.01726f
C129 a_2735_n7880# SH1 0
C130 SH4B a_484_n1792# 0.07228f
C131 A4 SH1B 0.05457f
C132 m2_n7_n276# m2_n7_n2502# 0
C133 OUT6 OUT7 0.01035f
C134 OUT5 SH8B 0.01034f
C135 m2_n7_n9922# SH1 0.02035f
C136 SH4B a_484_n9212# 0.02852f
C137 SH4 a_1337_n9945# 0.02366f
C138 OUT10 SH8B 0.01034f
C139 a_2735_n7880# OUT11 0.05555f
C140 a_484_n6244# m2_n7_n6212# 0.11174f
C141 a_2735_n9355# OUT13 0.05487f
C142 m2_n7_n3244# SH1 0.03766f
C143 a_484_n308# a_484_434# 1.12257f
C144 SH8 OUT13 0.01726f
C145 m2_n7_n8438# a_484_n8470# 0.17613f
C146 SH2B a_484_434# 0.01146f
C147 SH4 OUT8 0
C148 m2_n7_n10664# a_2735_n8622# 0
C149 a_484_n6986# m2_n7_n6212# 0.03545f
C150 SH1 A7 0.01558f
C151 a_484_n1050# a_484_434# 0.04848f
C152 A14 A15 0.03878f
C153 m2_n7_n7696# SH2B 0.09596f
C154 SH4B a_484_434# 0.08485f
C155 SH2 a_484_n1792# 0.06608f
C156 SH2B a_484_n308# 0.01289f
C157 SH8B a_2735_n10830# 0.01322f
C158 a_2735_n7880# a_2735_n8622# 1.36213f
C159 a_484_n6986# a_1337_n9945# 0.03526f
C160 A10 m2_n7_n7696# 0.04379f
C161 m2_n7_n9922# a_2735_n8622# 0
C162 A4 a_484_n2534# 0
C163 SH2 a_484_n9212# 0.02311f
C164 a_484_n7728# m2_n7_n6212# 0.03524f
C165 m2_n7_n1760# m2_n7_n1018# 0.45905f
C166 a_484_n9212# a_2735_n10830# 0.00393f
C167 a_484_n1050# a_484_n308# 1.44425f
C168 m2_n7_n7696# SH4B 0
C169 A10 SH2B 0
C170 SH4 SH8B 0.13147f
C171 SH4 a_484_n1792# 0.01512f
C172 SH4B a_484_n308# 0.10162f
C173 m2_n7_n5470# m2_n7_n6212# 0.45905f
C174 SH2B a_484_n1050# 0.01174f
C175 a_484_n7728# a_1337_n9945# 0.01186f
C176 a_2735_n9355# OUT14 0.00926f
C177 SH4 a_484_n9212# 0.00884f
C178 OUT14 SH8 0.01727f
C179 A2 m2_n7_n1018# 0.12891f
C180 m2_n7_n6954# m2_n7_n6212# 0.20728f
C181 a_484_n5502# OUT9 0
C182 OUT6 SH8 0.01727f
C183 a_2735_n9355# m2_n7_n9180# 0
C184 A10 SH4B 0
C185 OUT14 OUT15 0.01035f
C186 a_484_n10696# m2_n7_n9180# 0.03524f
C187 SH4B a_484_n1050# 0.08402f
C188 a_484_n5502# SH8 0
C189 a_484_n6244# SH8B 0
C190 m2_n7_n5470# A8 0.12891f
C191 m2_n7_466# SH1 0.01937f
C192 a_484_n9954# a_2735_n9355# 0
C193 m2_n7_n1018# SH1B 0.01328f
C194 SH2 a_484_434# 0.01949f
C195 m2_n7_n9922# m2_n7_n8438# 0.03117f
C196 a_484_n9954# SH8 0
C197 a_484_n6244# a_484_n9212# 0.02542f
C198 SH4B OUT5 0
C199 m2_n7_n276# m2_n7_466# 0.45905f
C200 a_484_n9954# a_484_n10696# 0.35611f
C201 OUT10 SH4B 0
C202 A4 m2_n7_n2502# 0.12891f
C203 a_484_n6986# SH8B 0
C204 A9 m2_n7_n6212# 0.14389f
C205 SH1B m2_n7_n6212# 0.0106f
C206 m2_n7_n7696# SH2 0.01949f
C207 SH4 a_484_434# 0.0262f
C208 SH2 a_484_n308# 0.02742f
C209 a_484_n6986# a_484_n9212# 0.16447f
C210 A0 m2_n7_466# 0.12891f
C211 A15 SH1 0.00978f
C212 A6 m2_n7_n4728# 0.04379f
C213 SH2B SH2 1.08645f
C214 SH8 OUT12 0.01727f
C215 SH2B a_2735_n10830# 0
C216 OUT14 OUT13 0.01047f
C217 SH1B a_1337_n9945# 0
C218 A4 m2_n7_n3244# 0.04379f
C219 a_2735_n9355# SH1 0
C220 a_484_n7728# SH8B 0
C221 SH1B A8 0.05457f
C222 m2_n7_n7696# SH4 0
C223 A9 A8 0.04228f
C224 A13 A14 0.04228f
C225 A10 SH2 0
C226 SH4 a_484_n308# 0.0189f
C227 A3 SH1 0.01558f
C228 SH2 a_484_n1050# 0.03861f
C229 a_484_n7728# a_484_n9212# 0.08918f
C230 SH4B SH2 0.29214f
C231 SH4B a_2735_n10830# 0.0103f
C232 SH8 OUT11 0.01726f
C233 m2_n7_n1760# a_484_n1792# 0.10709f
C234 a_484_n2534# m2_n7_n1018# 0.03526f
C235 m2_n7_n4728# a_484_n5502# 0.03474f
C236 m2_n7_n7696# a_484_n6244# 0
C237 SH4 a_484_n1050# 0.01656f
C238 A13 m2_n7_n9180# 0.14389f
C239 SH4B SH4 1.08652f
C240 A2 A1 0.04228f
C241 a_484_n8470# a_1337_n9945# 0.11079f
C242 SH2B a_484_n6244# 0.01289f
C243 A14 m2_n7_n9180# 0.00301f
C244 SH4 OUT5 0
C245 OUT10 SH4 0
C246 OUT12 OUT13 0.01035f
C247 A10 a_484_n6244# 0
C248 m2_n7_n7696# a_484_n6986# 0
C249 a_2735_n9355# a_2735_n8622# 1.02656f
C250 OUT0 SH8 0.0164f
C251 A13 A12 0.04228f
C252 a_484_n9954# A14 0
C253 a_2735_n8622# SH8 0.00835f
C254 A1 SH1B 0.05457f
C255 a_2735_n8622# a_484_n10696# 0
C256 SH4B a_484_n6244# 0.10162f
C257 SH2B a_484_n6986# 0.01174f
C258 OUT2 SH8B 0.01034f
C259 OUT15 a_2735_n8622# 0
C260 a_484_n9212# SH1B 0.00117f
C261 SH2 a_2735_n10830# 0
C262 m2_n7_n1760# a_484_434# 0
C263 A10 a_484_n6986# 0
C264 m2_n7_n7696# a_484_n7728# 0.10709f
C265 OUT10 a_484_n6244# 0
C266 m2_n7_n4728# SH1 0.03766f
C267 m2_n7_n1018# m2_n7_n2502# 0.03117f
C268 a_484_n3276# A8 0
C269 a_484_n4018# m2_n7_n6212# 0
C270 SH4B a_484_n6986# 0.08402f
C271 OUT2 OUT1 0.01047f
C272 SH2B a_484_n7728# 0.01057f
C273 A13 SH1 0.01558f
C274 a_484_n9954# m2_n7_n9180# 0.03545f
C275 m2_n7_n3986# a_484_n1792# 0.00431f
C276 SH4 a_2735_n10830# 0.02218f
C277 A2 a_484_434# 0
C278 m2_n7_n1760# a_484_n308# 0
C279 A12 m2_n7_n9180# 0.04379f
C280 A14 SH1 0.01558f
C281 m2_n7_n7696# m2_n7_n6954# 0.45905f
C282 m2_n7_n10664# a_1337_n9945# 0
C283 A6 SH1 0.01558f
C284 SH2B m2_n7_n5470# 0.06873f
C285 SH2B m2_n7_n1760# 0.09596f
C286 a_2735_n9355# m2_n7_n8438# 0
C287 SH8B a_484_n8470# 0
C288 SH4B a_484_n7728# 0.07176f
C289 a_484_n4018# A8 0
C290 a_484_n4760# m2_n7_n6212# 0
C291 a_484_n3276# OUT8 0
C292 SH2B m2_n7_n6954# 0.06873f
C293 a_2735_n7880# a_1337_n9945# 0.04256f
C294 a_2735_n8622# OUT13 0.00948f
C295 a_484_n9212# a_484_n8470# 1.00551f
C296 SH2 a_484_n6244# 0.02742f
C297 m2_n7_n1760# a_484_n1050# 0
C298 A2 a_484_n308# 0
C299 m2_n7_n9922# a_1337_n9945# 0
C300 A10 m2_n7_n6954# 0.12891f
C301 SH4B m2_n7_n5470# 0.00101f
C302 a_484_n2534# SH8B 0
C303 a_484_n2534# a_484_n1792# 0.12971f
C304 SH4B m2_n7_n1760# 0
C305 SH2B A2 0
C306 SH1 m2_n7_n9180# 0.03766f
C307 A4 A3 0.04228f
C308 SH4B m2_n7_n6954# 0
C309 a_484_n4760# A8 0
C310 m2_n7_n7696# SH1B 0.0106f
C311 SH4 a_484_n6244# 0.01903f
C312 a_484_n308# SH1B 0.00117f
C313 SH2 a_484_n6986# 0.03861f
C314 A12 A11 0.04228f
C315 A2 a_484_n1050# 0
C316 a_484_n3276# SH8B 0
C317 a_484_n3276# a_484_n1792# 0.09086f
C318 a_484_n5502# OUT11 0
C319 SH4B A2 0
C320 OUT4 SH8 0.01727f
C321 SH1 A12 0.01558f
C322 A5 SH1B 0.05457f
C323 A10 SH1B 0.05457f
C324 A10 A9 0.04228f
C325 SH4 a_484_n6986# 0.0167f
C326 a_484_n1050# SH1B 0
C327 SH2 a_484_n7728# 0.06608f
C328 A8 A7 0.04228f
C329 a_484_n7728# a_2735_n10830# 0.03529f
C330 a_484_n4018# SH8B 0
C331 a_484_n4018# a_484_n1792# 0.17894f
C332 SH1 A11 0.01558f
C333 m2_n7_n10664# a_484_n9212# 0
C334 a_484_n2534# a_484_434# 0.03117f
C335 OUT4 OUT3 0.01047f
C336 OUT14 a_2735_n8622# 0
C337 SH2B m2_n7_n3986# 0.06873f
C338 SH2 m2_n7_n5470# 0.0207f
C339 a_484_n1792# m2_n7_n2502# 0.0105f
C340 m2_n7_n7696# a_484_n8470# 0.03474f
C341 SH2 m2_n7_n1760# 0.01949f
C342 a_2735_n7880# SH8B 0.02148f
C343 A5 m2_n7_n3986# 0.04379f
C344 a_2735_n8622# m2_n7_n9180# 0
C345 SH4 a_484_n7728# 0.01525f
C346 m2_n7_n1018# m2_n7_466# 0.03117f
C347 SH2 m2_n7_n6954# 0.02076f
C348 OUT12 OUT11 0.01047f
C349 a_484_n6986# a_484_n6244# 1.44425f
C350 a_2735_n7880# a_484_n9212# 0
C351 a_2735_n8622# a_484_n5502# 0.03526f
C352 m2_n7_n276# SH1 0.03766f
C353 a_484_n4760# a_484_n1792# 0.02705f
C354 a_484_n4760# SH8B 0
C355 SH2B a_484_n8470# 0.01146f
C356 A13 m2_n7_n8438# 0
C357 m2_n7_n9922# a_484_n9212# 0.00146f
C358 SH4B m2_n7_n3986# 0
C359 SH4 m2_n7_n5470# 0
C360 a_484_n2534# a_484_n308# 0.16607f
C361 SH4 m2_n7_n1760# 0
C362 a_484_n1792# m2_n7_n3244# 0
C363 a_484_n9954# a_2735_n8622# 0
C364 SH2 A2 0
C365 SH4 m2_n7_n6954# 0
C366 SH2B a_484_n2534# 0.01146f
C367 OUT8 OUT7 0.01048f
C368 a_484_n7728# a_484_n6244# 0.0616f
C369 A0 SH1 0.01558f
C370 SH4B a_484_n8470# 0.05879f
C371 A0 m2_n7_n276# 0.04379f
C372 a_484_n2534# a_484_n1050# 0.08718f
C373 a_484_n3276# a_484_n308# 0.02542f
C374 SH1B a_2735_n10830# 0
C375 m2_n7_n5470# a_484_n6244# 0.06318f
C376 SH4B a_484_n2534# 0.08528f
C377 SH2B a_484_n3276# 0.01289f
C378 m2_n7_n8438# m2_n7_n9180# 0.45905f
C379 a_2735_n8622# OUT12 0.05488f
C380 a_484_n7728# a_484_n6986# 1.79123f
C381 m2_n7_n6954# a_484_n6244# 0.00146f
C382 A5 a_484_n3276# 0
C383 OUT5 a_484_n2534# 0
C384 A3 m2_n7_n1018# 0
C385 a_484_n3276# a_484_n1050# 0.16447f
C386 SH8B OUT7 0.01034f
C387 m2_n7_n5470# a_484_n6986# 0.03526f
C388 SH2B m2_n7_n10664# 0.01973f
C389 a_484_n9954# m2_n7_n8438# 0.03526f
C390 SH4B a_484_n3276# 0.10162f
C391 a_2735_n7880# m2_n7_n7696# 0
C392 SH2 m2_n7_n3986# 0.02076f
C393 SH2B a_484_n4018# 0.01174f
C394 a_484_n308# m2_n7_n2502# 0.0024f
C395 m2_n7_n8438# A12 0.12891f
C396 m2_n7_n6954# a_484_n6986# 0.19703f
C397 m2_n7_n7696# m2_n7_n9922# 0
C398 a_2735_n9355# a_1337_n9945# 0.69668f
C399 SH2B m2_n7_n2502# 0.06873f
C400 SH8 a_1337_n9945# 0.00835f
C401 a_2735_n7880# SH2B 0
C402 a_484_n10696# a_1337_n9945# 0
C403 A5 m2_n7_n2502# 0
C404 a_484_n4018# a_484_n1050# 0.02473f
C405 a_484_n8470# a_2735_n10830# 0.06351f
C406 SH2 a_484_n8470# 0.02023f
C407 A9 a_484_n6244# 0
C408 SH4B m2_n7_n10664# 0
C409 a_484_n6244# SH1B 0.00117f
C410 SH2B m2_n7_n9922# 0.04224f
C411 OUT15 a_1337_n9945# 0.00907f
C412 SH4 m2_n7_n3986# 0
C413 SH4B a_484_n4018# 0.08402f
C414 m2_n7_n8438# A11 0.04379f
C415 SH2B a_484_n4760# 0.01057f
C416 a_484_n1050# m2_n7_n2502# 0.00785f
C417 m2_n7_n6954# a_484_n7728# 0.08396f
C418 OUT9 OUT8 0.01035f
C419 A1 m2_n7_466# 0
C420 SH4B m2_n7_n2502# 0.00101f
C421 SH2 a_484_n2534# 0.02023f
C422 m2_n7_n8438# SH1 0.02035f
C423 A10 a_484_n4760# 0
C424 a_2735_n7880# SH4B 0.01206f
C425 SH2B m2_n7_n3244# 0.09596f
C426 SH4 a_484_n8470# 0.02135f
C427 A5 m2_n7_n3244# 0.14389f
C428 SH4B m2_n7_n9922# 0
C429 a_484_n6986# SH1B 0
C430 SH8 OUT8 0.01726f
C431 m2_n7_n5470# m2_n7_n6954# 0.03117f
C432 SH4B a_484_n4760# 0.07228f
C433 a_484_n1050# m2_n7_n3244# 0
C434 A4 SH1 0.01558f
C435 SH4 a_484_n2534# 0.0264f
C436 SH2 a_484_n3276# 0.02742f
C437 SH4B m2_n7_n3244# 0
C438 A2 m2_n7_n1760# 0.04379f
C439 a_484_n6244# a_484_n8470# 0.16607f
C440 SH8B OUT9 0.01034f
C441 m2_n7_n4728# m2_n7_n6212# 0.02712f
C442 SH2 m2_n7_n10664# 0.00893f
C443 a_2735_n9355# SH8B 0.01871f
C444 m2_n7_n10664# a_2735_n10830# 0
C445 SH4 a_484_n3276# 0.01896f
C446 SH8B SH8 1.08425f
C447 m2_n7_n5470# SH1B 0.01328f
C448 SH2 a_484_n4018# 0.03861f
C449 A9 m2_n7_n5470# 0
C450 a_484_n10696# SH8B 0
C451 m2_n7_n1760# SH1B 0.0106f
C452 a_2735_n9355# a_484_n9212# 0.07634f
C453 a_484_n6986# a_484_n8470# 0.08718f
C454 a_484_434# m2_n7_466# 0.17613f
C455 a_484_n9212# SH8 0
C456 m2_n7_n6954# SH1B 0.01328f
C457 A9 m2_n7_n6954# 0.04379f
C458 SH2 m2_n7_n2502# 0.0207f
C459 OUT15 SH8B 0.00991f
C460 a_484_n10696# a_484_n9212# 0.06144f
C461 a_2735_n7880# SH2 0
C462 a_2735_n7880# a_2735_n10830# 0.06221f
C463 m2_n7_n4728# A8 0.00301f
C464 a_2735_n8622# m2_n7_n8438# 0
C465 SH4 m2_n7_n10664# 0
C466 SH2 m2_n7_n9922# 0.01528f
C467 m2_n7_n9922# a_2735_n10830# 0
C468 OUT15 a_484_n9212# 0
C469 SH4 a_484_n4018# 0.01663f
C470 OUT1 SH8 0.01726f
C471 SH4B OUT7 0
C472 SH2 a_484_n4760# 0.06608f
C473 a_484_n3276# a_484_n6244# 0.02542f
C474 A2 SH1B 0.05457f
C475 OUT3 SH8B 0.01034f
C476 m2_n7_n3986# m2_n7_n5470# 0.03117f
C477 SH4 m2_n7_n2502# 0
C478 a_484_n308# m2_n7_466# 0.06318f
C479 m2_n7_n1760# m2_n7_n3986# 0
C480 a_484_n7728# a_484_n8470# 0.12627f
C481 a_2735_n7880# SH4 0.02322f
C482 SH2 m2_n7_n3244# 0.01946f
C483 SH4 m2_n7_n9922# 0
C484 SH2B m2_n7_466# 0.06833f
C485 SH4 a_484_n4760# 0.01518f
C486 A9 SH1B 0.05457f
C487 a_484_n4018# a_484_n6244# 0.16447f
C488 a_484_n5502# m2_n7_n6212# 0
C489 OUT14 a_1337_n9945# 0.05488f
C490 m2_n7_n6954# a_484_n8470# 0.03526f
C491 SH4 m2_n7_n3244# 0
C492 a_484_n1050# m2_n7_466# 0.03526f
C493 SH8B OUT13 0.01034f
C494 m2_n7_n9180# a_1337_n9945# 0
C495 a_2735_n7880# a_484_n6244# 0.00492f
C496 SH4B m2_n7_466# 0.00101f
C497 m2_n7_n1760# a_484_n2534# 0.03474f
C498 a_484_n5502# A8 0
C499 a_484_n4018# a_484_n6986# 0.02473f
C500 a_484_n4760# a_484_n6244# 0.09086f
C501 a_484_n9954# a_1337_n9945# 0.07673f
C502 m2_n7_n3986# SH1B 0.01328f
C503 m2_n7_n1018# SH1 0.02035f
C504 SH2B a_2735_n9355# 0
C505 a_2735_n7880# a_484_n6986# 0.01172f
C506 a_484_n3276# m2_n7_n5470# 0.0024f
C507 m2_n7_n1760# a_484_n3276# 0.03524f
C508 SH2B a_484_n10696# 0.01009f
C509 m2_n7_n276# m2_n7_n1018# 0.20728f
C510 a_484_n4760# a_484_n6986# 0.17894f
C511 SH4B OUT9 0
C512 A13 a_484_n9212# 0
C513 A6 a_484_n1792# 0
C514 SH1 m2_n7_n6212# 0.03766f
C515 SH4 OUT7 0
C516 SH4B a_2735_n9355# 0.01142f
C517 A14 a_484_n9212# 0
C518 a_2735_n7880# a_484_n7728# 0.08445f
C519 OUT10 OUT9 0.01047f
C520 a_484_n4018# m2_n7_n5470# 0.00785f
C521 SH4B a_484_n10696# 0.01427f
C522 m2_n7_n9922# a_484_n7728# 0.00431f
C523 OUT5 SH8 0.01726f
C524 SH1 a_1337_n9945# 0
C525 a_484_n4760# a_484_n7728# 0.02705f
C526 SH2 m2_n7_466# 0.0207f
C527 OUT14 SH8B 0.01034f
C528 SH4B OUT15 0
C529 OUT10 SH8 0.01727f
C530 OUT6 SH8B 0.01034f
C531 m2_n7_n1760# m2_n7_n2502# 0.20728f
C532 SH1 A8 0.01558f
C533 OUT14 a_484_n9212# 0
C534 a_2735_n7880# m2_n7_n6954# 0
C535 a_484_n4760# m2_n7_n5470# 0.0105f
C536 a_484_n3276# SH1B 0.00117f
C537 a_484_n5502# SH8B 0
C538 a_484_n5502# a_484_n1792# 0
C539 a_484_n9212# m2_n7_n9180# 0.11174f
C540 m2_n7_n3986# a_484_n2534# 0
C541 SH4 m2_n7_466# 0
C542 a_484_n4760# m2_n7_n6954# 0.00431f
C543 m2_n7_n5470# m2_n7_n3244# 0
C544 a_484_n9954# SH8B 0
C545 m2_n7_n1760# m2_n7_n3244# 0.02712f
C546 m2_n7_n10664# SH1B 0.01011f
C547 a_484_n9954# a_484_n9212# 0.66545f
C548 a_484_n4018# SH1B 0
C549 SH2 a_2735_n9355# 0
C550 SH2B m2_n7_n4728# 0.09596f
C551 a_2735_n9355# a_2735_n10830# 0.06314f
C552 m2_n7_n3986# a_484_n3276# 0.00146f
C553 SH4B OUT13 0
C554 m2_n7_n5470# A7 0.04379f
C555 SH8 a_2735_n10830# 0.00794f
C556 m2_n7_n2502# SH1B 0.01328f
C557 SH2 a_484_n10696# 0.02188f
C558 a_484_n10696# a_2735_n10830# 0.07838f
C559 a_2735_n7880# SH1B 0
C560 m2_n7_n9922# SH1B 0.01328f
C561 a_2735_n8622# a_1337_n9945# 0.04293f
C562 SH8B OUT12 0.01034f
C563 SH4 OUT9 0
C564 OUT15 a_2735_n10830# 0.05487f
C565 SH2B A14 0
C566 SH4 a_2735_n9355# 0.02328f
C567 SH4B m2_n7_n4728# 0
C568 A1 SH1 0.01558f
C569 SH2B A6 0
C570 m2_n7_n3986# a_484_n4018# 0.19703f
C571 SH4 a_484_n10696# 0.00843f
C572 A6 A5 0.04228f
C573 m2_n7_n3244# SH1B 0.0106f
C574 A1 m2_n7_n276# 0.14389f
C575 m2_n7_n276# a_484_n1792# 0.03524f
C576 a_484_n9212# SH1 0
C577 a_484_n3276# a_484_n2534# 1.12257f
C578 SH8B OUT11 0.01034f
C579 SH4 OUT15 0
C580 m2_n7_n3986# m2_n7_n2502# 0.03117f
C581 m2_n7_n10664# a_484_n8470# 0
C582 m2_n7_n7696# m2_n7_n9180# 0.02712f
C583 m2_n7_n8438# m2_n7_n6212# 0
C584 SH4B A14 0
C585 SH4B A6 0
C586 m2_n7_n7696# a_484_n5502# 0
C587 a_2735_n9355# a_484_n6244# 0.03529f
C588 m2_n7_n3986# a_484_n4760# 0.08396f
C589 SH1B A7 0.05457f
C590 a_484_n6244# SH8 0
C591 A1 A0 0.04228f
C592 SH2B m2_n7_n9180# 0.09543f
C593 a_2735_n7880# a_484_n8470# 0
C594 a_484_n4018# a_484_n2534# 0.04848f
C595 m2_n7_n9922# a_484_n8470# 0
C596 SH2B a_484_n5502# 0.01146f
C597 m2_n7_n3986# m2_n7_n3244# 0.20728f
C598 m2_n7_n7696# A12 0.00301f
C599 a_484_n4760# a_484_n8470# 0
C600 SH4B OUT14 0
C601 a_484_n2534# m2_n7_n2502# 0.17613f
C602 A10 a_484_n5502# 0
C603 SH4B OUT6 0
C604 a_484_n9954# SH2B 0.01174f
C605 a_2735_n9355# a_484_n6986# 0.01606f
C606 SH4B m2_n7_n9180# 0
C607 a_484_n6986# SH8 0
C608 OUT6 OUT5 0.01047f
C609 SH2B A12 0
C610 OUT0 SH8B 0.01034f
C611 SH2 m2_n7_n4728# 0.01949f
C612 a_2735_n8622# SH8B 0.01983f
C613 a_484_n4760# a_484_n2534# 0.06976f
C614 a_484_n4018# a_484_n3276# 1.44425f
C615 m2_n7_n3986# A7 0
C616 SH4B a_484_n5502# 0.08528f
C617 SH4 OUT13 0
C618 m2_n7_n276# a_484_434# 0
C619 m2_n7_n7696# A11 0.14389f
C620 a_2735_n8622# a_484_n9212# 0
C621 a_484_n3276# m2_n7_n2502# 0.06318f
C622 a_484_n2534# m2_n7_n3244# 0
C623 a_484_n9954# SH4B 0.02028f
C624 OUT10 a_484_n5502# 0
C625 a_2735_n9355# a_484_n7728# 0.00126f
C626 m2_n7_n7696# SH1 0.03766f
C627 SH4B A12 0
C628 a_484_n7728# SH8 0
C629 SH2 A14 0
C630 SH4 m2_n7_n4728# 0
C631 OUT1 OUT0 0.01035f
C632 a_484_n308# SH1 0
C633 a_484_n10696# a_484_n7728# 0.02705f
C634 SH2 A6 0
C635 a_484_n4760# a_484_n3276# 0.0616f
C636 m2_n7_n276# a_484_n308# 0.11174f
C637 A0 a_484_434# 0
C638 SH2B SH1 0.73606f
C639 A10 A11 0.04228f
C640 a_484_n4018# m2_n7_n2502# 0.03526f
C641 a_484_n3276# m2_n7_n3244# 0.11174f
C642 A5 SH1 0.01558f
C643 m2_n7_466# SH1B 0.01328f
C644 SH2B m2_n7_n276# 0.09596f
C645 m2_n7_n9922# m2_n7_n10664# 0.33786f
C646 A10 SH1 0.01558f
C647 SH4B OUT12 0
C648 A3 m2_n7_n1760# 0.14389f
C649 m2_n7_n4728# a_484_n6244# 0.03524f
C650 a_484_n4760# a_484_n4018# 1.79123f
C651 SH2 m2_n7_n9180# 0.01946f
C652 m2_n7_n276# a_484_n1050# 0.03545f
C653 a_484_n2534# OUT7 0
C654 SH2 a_484_n5502# 0.02023f
C655 a_484_n4018# m2_n7_n3244# 0.03545f
C656 m2_n7_n8438# a_484_n9212# 0.06318f
C657 SH4B m2_n7_n276# 0
C658 a_2735_n7880# a_484_n4760# 0.03529f
C659 SH2B A0 0
C660 SH4B OUT11 0
C661 A3 A2 0.04228f
C662 SH4 OUT14 0
C663 A4 a_484_n1792# 0
C664 A15 SH1B 0.02539f
C665 SH4 OUT6 0
C666 m2_n7_n3244# m2_n7_n2502# 0.45905f
C667 a_484_n9954# SH2 0.02332f
C668 a_484_n9954# a_2735_n10830# 0.01085f
C669 SH4 m2_n7_n9180# 0
C670 SH2 A12 0
C671 a_2735_n9355# SH1B 0
C672 OUT10 OUT11 0.01035f
C673 SH4 a_484_n5502# 0.0266f
C674 a_484_n3276# OUT7 0
C675 a_484_n4760# m2_n7_n3244# 0.03524f
C676 OUT2 SH8 0.01727f
C677 SH4B A0 0
C678 A3 SH1B 0.05457f
C679 OUT4 SH8B 0.01034f
C680 a_484_n9954# SH4 0.00884f
C681 a_484_n5502# a_484_n6244# 1.12257f
C682 m2_n7_n4728# m2_n7_n5470# 0.20728f
C683 SH1 a_2735_n10830# 0
C684 SH4B a_2735_n8622# 0.0114f
C685 OUT3 OUT2 0.01035f
C686 A14 a_484_n7728# 0
C687 SH2 m2_n7_n276# 0.01946f
C688 m2_n7_n4728# m2_n7_n6954# 0
C689 SH4 OUT12 0
C690 a_484_n6986# m2_n7_n9180# 0
C691 a_484_n6244# A12 0
C692 m2_n7_n7696# m2_n7_n8438# 0.20728f
C693 a_2735_n9355# a_484_n8470# 0.10341f
C694 SH8 a_484_n8470# 0
C695 a_484_n10696# a_484_n8470# 0.06581f
C696 a_484_n5502# a_484_n6986# 0.04848f
C697 A8 m2_n7_n6212# 0.04379f
C698 SH2B m2_n7_n8438# 0.06873f
C699 OUT15 a_484_n8470# 0
C700 SH4 m2_n7_n276# 0
C701 SH2 A0 0
C702 a_484_n9954# a_484_n6986# 0.02473f
C703 a_484_n2534# SH8 0
C704 SH4 OUT11 0
C705 A4 a_484_n308# 0
C706 a_484_n7728# m2_n7_n9180# 0
C707 a_484_n6986# A12 0
C708 a_484_n6244# OUT12 0
C709 a_484_n5502# a_484_n7728# 0.06976f
C710 SH2B A4 0
C711 m2_n7_n4728# SH1B 0.0106f
C712 a_484_n6244# SH1 0
C713 A5 A4 0.04228f
C714 SH4B m2_n7_n8438# 0.00101f
C715 a_484_n9954# a_484_n7728# 0.17894f
C716 a_484_n3276# SH8 0
C717 a_2735_n8622# a_2735_n10830# 0.06249f
C718 m2_n7_n5470# a_484_n5502# 0.17613f
C719 A4 a_484_n1050# 0
C720 OUT4 a_484_n308# 0
C721 A13 SH1B 0.05457f
C722 a_484_n6244# OUT11 0
C723 a_484_n7728# A12 0
C724 m2_n7_n10664# A15 0.14359f
C725 A1 m2_n7_n1018# 0.04379f
C726 SH4B A4 0
C727 m2_n7_n1018# a_484_n1792# 0.08396f
C728 A14 SH1B 0.05457f
C729 a_484_n5502# m2_n7_n6954# 0
C730 A6 SH1B 0.05457f
C731 a_484_n10696# GND 0.69733f
C732 m2_n7_n8438# GND 0.62155f
C733 a_484_n5502# GND 0.65831f
C734 a_484_n6244# GND 0.77284f
C735 a_484_n6986# GND 0.84221f
C736 a_484_n7728# GND 3.77629f
C737 m2_n7_n6954# GND 0.61083f
C738 m2_n7_n5470# GND 0.62143f
C739 A9 GND 0.42559f
C740 a_484_n2534# GND 0.66183f
C741 a_484_n3276# GND 0.77146f
C742 a_484_n4018# GND 0.84065f
C743 a_484_n4760# GND 3.78521f
C744 m2_n7_n3986# GND 0.61091f
C745 m2_n7_n2502# GND 0.62178f
C746 m2_n7_n3244# GND 1.82018f
C747 a_484_434# GND 1.22724f
C748 a_484_n308# GND 1.08505f
C749 a_484_n1050# GND 1.04118f
C750 a_484_n1792# GND 3.80923f
C751 m2_n7_n1018# GND 0.61524f
C752 m2_n7_466# GND 0.93739f
C753 A15 GND 0.35423f
C754 OUT15 GND 0.17433f
C755 m2_n7_n10664# GND 0.6389f
C756 A14 GND 0.4367f
C757 OUT14 GND 0.15622f
C758 A13 GND 0.42559f
C759 OUT13 GND 0.15516f
C760 m2_n7_n9180# GND 1.82594f
C761 A12 GND 0.43285f
C762 OUT12 GND 0.15317f
C763 A11 GND 0.42559f
C764 OUT11 GND 0.15053f
C765 m2_n7_n7696# GND 1.82156f
C766 A10 GND 0.43335f
C767 OUT10 GND 0.14746f
C768 OUT9 GND 0.14408f
C769 m2_n7_n6212# GND 1.82018f
C770 A8 GND 0.43285f
C771 OUT8 GND 0.13894f
C772 A7 GND 0.42559f
C773 OUT7 GND 0.19434f
C774 m2_n7_n4728# GND 1.82166f
C775 A6 GND 0.43335f
C776 OUT6 GND 0.19404f
C777 A5 GND 0.42559f
C778 OUT5 GND 0.19412f
C779 A4 GND 0.43285f
C780 OUT4 GND 0.19357f
C781 A3 GND 0.42559f
C782 OUT3 GND 0.19302f
C783 m2_n7_n1760# GND 1.8216f
C784 A2 GND 0.43351f
C785 OUT2 GND 0.19326f
C786 A1 GND 0.42559f
C787 OUT1 GND 0.19574f
C788 m2_n7_n276# GND 1.84826f
C789 A0 GND 0.47628f
C790 OUT0 GND 0.22444f
C791 SH8 GND 9.37549f
C792 SH8B GND 8.90568f
C793 SH4 GND 9.40666f
C794 SH4B GND 8.58078f
C795 SH2 GND 9.09978f
C796 SH2B GND 8.07676f
C797 SH1 GND 8.53461f
C798 SH1B GND 8.69758f
C799 a_2735_n7147.t1 GND 0.01564f
C800 a_2735_n7147.t2 GND 0.01502f
C801 a_2735_n7147.n0 GND 1.15642f
C802 a_2735_n7147.t0 GND 0.81291f
C803 a_2735_n6735.t1 GND 1.63456f
C804 a_2735_n6735.t2 GND 0.03332f
C805 a_2735_n6735.t3 GND 0.03201f
C806 a_2735_n6735.n0 GND 0.14199f
C807 a_2735_n6735.n1 GND 3.93677f
C808 a_2735_n6735.t0 GND 0.12136f
C809 a_2735_n506.t1 GND 1.30263f
C810 a_2735_n506.t2 GND 0.03049f
C811 a_2735_n506.t3 GND 0.02929f
C812 a_2735_n506.n0 GND 0.14039f
C813 a_2735_n506.n1 GND 3.69303f
C814 a_2735_n506.t0 GND 0.10417f
C815 a_2735_227.t1 GND 0.53398f
C816 a_2735_227.t2 GND 0.01459f
C817 a_2735_227.t3 GND 0.01402f
C818 a_2735_227.n0 GND 0.07256f
C819 a_2735_227.n1 GND 1.81397f
C820 a_2735_227.t0 GND 0.05089f
C821 a_2735_n8951.t1 GND 2.86522f
C822 a_2735_n8951.t2 GND 0.04286f
C823 a_2735_n8951.t3 GND 0.04117f
C824 a_2735_n8951.n0 GND 0.14497f
C825 a_2735_n8951.n1 GND 4.63822f
C826 a_2735_n8951.t0 GND 0.16756f
C827 a_2735_n9685.t1 GND 3.2997f
C828 a_2735_n9685.t2 GND 0.04541f
C829 a_2735_n9685.t3 GND 0.04362f
C830 a_2735_n9685.n0 GND 0.14374f
C831 a_2735_n9685.n1 GND 4.77556f
C832 a_2735_n9685.t0 GND 0.19197f
C833 a_2735_n5672.t1 GND 0.0151f
C834 a_2735_n5672.t2 GND 0.01451f
C835 a_2735_n5672.n0 GND 1.37582f
C836 a_2735_n5672.t0 GND 0.99457f
C837 a_2735_n6405.t1 GND 0.03074f
C838 a_2735_n6405.t2 GND 0.02953f
C839 a_2735_n6405.n0 GND 2.53684f
C840 a_2735_n6405.t0 GND 1.80288f
C841 a_2735_n7476.t1 GND 2.02161f
C842 a_2735_n7476.t2 GND 0.03682f
C843 a_2735_n7476.t3 GND 0.03536f
C844 a_2735_n7476.n0 GND 0.14538f
C845 a_2735_n7476.n1 GND 4.22763f
C846 a_2735_n7476.t0 GND 0.13319f
C847 a_2735_n4931.t1 GND 1.82257f
C848 a_2735_n4931.t2 GND 0.02319f
C849 a_2735_n4931.t3 GND 0.02227f
C850 a_2735_n4931.n0 GND 0.06911f
C851 a_2735_n4931.n1 GND 2.36343f
C852 a_2735_n4931.t0 GND 0.09943f
C853 a_2735_n8210.t1 GND 2.44282f
C854 a_2735_n8210.t2 GND 0.04017f
C855 a_2735_n8210.t3 GND 0.03858f
C856 a_2735_n8210.n0 GND 0.14587f
C857 a_2735_n8210.n1 GND 4.47629f
C858 a_2735_n8210.t0 GND 0.15626f
C859 a_2735_n10830# GND 0.80496f
C860 m2_n7_n9922# GND 0.54157f
C861 a_2735_n7880# GND 0.64591f
C862 a_484_n9954# GND 0.47392f
C863 a_484_n9212# GND 0.52736f
C864 a_484_n8470# GND 0.58261f
C865 a_2735_n8622# GND 0.58869f
C866 a_2735_n9355# GND 0.59325f
C867 a_1337_n9945# GND 0.58753f
.ends
