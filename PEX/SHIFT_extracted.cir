* Extracted by KLayout with GF180MCU LVS runset on : 11/04/2026 01:18

.SUBCKT SHIFT A15 GND SH1 SH2 SH4 SH8 SH1B A14 SH2B SH4B SH8B OUT15 A13 OUT14
+ A12 OUT13 OUT12 A11 OUT11 A10 OUT10 A9 OUT9 A8 OUT8 A7 A6 OUT7 A5 OUT6 A4
+ OUT5 A3 OUT4 OUT3 A2 OUT2 A1 A0 OUT1 OUT0
M$1 \$3 SH1 A15 GND nfet_03v3 L=0.28U W=0.5U AS=0.3775P AD=0.18625P PS=2.51U
+ PD=1.245U
M$2 A14 SH1B \$3 GND nfet_03v3 L=0.28U W=0.5U AS=0.18625P AD=0.2625P PS=1.245U
+ PD=2.05U
M$3 \$4 SH2 \$3 GND nfet_03v3 L=0.28U W=0.5U AS=0.355P AD=0.18625P PS=2.42U
+ PD=1.245U
M$4 \$31 SH2B \$4 GND nfet_03v3 L=0.28U W=0.5U AS=0.18625P AD=0.2625P PS=1.245U
+ PD=2.05U
M$5 \$9 SH4 \$4 GND nfet_03v3 L=0.28U W=0.5U AS=0.3575P AD=0.18625P PS=2.43U
+ PD=1.245U
M$6 \$54 SH4B \$9 GND nfet_03v3 L=0.28U W=0.5U AS=0.18625P AD=0.27P PS=1.245U
+ PD=2.08U
M$7 OUT15 SH8 \$9 GND nfet_03v3 L=0.28U W=0.5U AS=0.3575P AD=0.18625P PS=2.43U
+ PD=1.245U
M$8 \$20 SH8B OUT15 GND nfet_03v3 L=0.28U W=0.5U AS=0.18625P AD=0.27P PS=1.245U
+ PD=2.08U
M$9 \$28 SH1 A14 GND nfet_03v3 L=0.28U W=0.5U AS=0.3775P AD=0.18625P PS=2.51U
+ PD=1.245U
M$10 A13 SH1B \$28 GND nfet_03v3 L=0.28U W=0.5U AS=0.18625P AD=0.2625P
+ PS=1.245U PD=2.05U
M$11 \$26 SH2 \$28 GND nfet_03v3 L=0.28U W=0.5U AS=0.3775P AD=0.18625P PS=2.51U
+ PD=1.245U
M$12 \$48 SH2B \$26 GND nfet_03v3 L=0.28U W=0.5U AS=0.18625P AD=0.2625P
+ PS=1.245U PD=2.05U
M$13 \$29 SH4 \$26 GND nfet_03v3 L=0.28U W=0.5U AS=0.3775P AD=0.18625P PS=2.51U
+ PD=1.245U
M$14 \$32 SH4B \$29 GND nfet_03v3 L=0.28U W=0.5U AS=0.18625P AD=0.2625P
+ PS=1.245U PD=2.05U
M$15 OUT14 SH8 \$29 GND nfet_03v3 L=0.28U W=0.5U AS=0.3775P AD=0.18625P
+ PS=2.51U PD=1.245U
M$16 \$33 SH8B OUT14 GND nfet_03v3 L=0.28U W=0.5U AS=0.18625P AD=0.2625P
+ PS=1.245U PD=2.05U
M$17 \$31 SH1 A13 GND nfet_03v3 L=0.28U W=0.5U AS=0.3775P AD=0.18625P PS=2.51U
+ PD=1.245U
M$18 A12 SH1B \$31 GND nfet_03v3 L=0.28U W=0.5U AS=0.18625P AD=0.2625P
+ PS=1.245U PD=2.05U
M$19 \$5 SH2 \$31 GND nfet_03v3 L=0.28U W=0.5U AS=0.355P AD=0.18625P PS=2.42U
+ PD=1.245U
M$20 \$52 SH2B \$5 GND nfet_03v3 L=0.28U W=0.5U AS=0.18625P AD=0.2625P
+ PS=1.245U PD=2.05U
M$21 \$10 SH4 \$5 GND nfet_03v3 L=0.28U W=0.5U AS=0.3575P AD=0.18625P PS=2.43U
+ PD=1.245U
M$22 \$40 SH4B \$10 GND nfet_03v3 L=0.28U W=0.5U AS=0.18625P AD=0.27P PS=1.245U
+ PD=2.08U
M$23 OUT13 SH8 \$10 GND nfet_03v3 L=0.28U W=0.5U AS=0.3575P AD=0.18625P
+ PS=2.43U PD=1.245U
M$24 \$42 SH8B OUT13 GND nfet_03v3 L=0.28U W=0.5U AS=0.18625P AD=0.27P
+ PS=1.245U PD=2.08U
M$25 \$48 SH1 A12 GND nfet_03v3 L=0.28U W=0.5U AS=0.3775P AD=0.18625P PS=2.51U
+ PD=1.245U
M$26 A11 SH1B \$48 GND nfet_03v3 L=0.28U W=0.5U AS=0.18625P AD=0.2625P
+ PS=1.245U PD=2.05U
M$27 \$46 SH2 \$48 GND nfet_03v3 L=0.28U W=0.5U AS=0.3775P AD=0.18625P PS=2.51U
+ PD=1.245U
M$28 \$53 SH2B \$46 GND nfet_03v3 L=0.28U W=0.5U AS=0.18625P AD=0.2625P
+ PS=1.245U PD=2.05U
M$29 \$49 SH4 \$46 GND nfet_03v3 L=0.28U W=0.5U AS=0.3775P AD=0.18625P PS=2.51U
+ PD=1.245U
M$30 \$55 SH4B \$49 GND nfet_03v3 L=0.28U W=0.5U AS=0.18625P AD=0.2625P
+ PS=1.245U PD=2.05U
M$31 OUT12 SH8 \$49 GND nfet_03v3 L=0.28U W=0.5U AS=0.3775P AD=0.18625P
+ PS=2.51U PD=1.245U
M$32 \$118 SH8B OUT12 GND nfet_03v3 L=0.28U W=0.5U AS=0.18625P AD=0.2625P
+ PS=1.245U PD=2.05U
M$33 \$52 SH1 A11 GND nfet_03v3 L=0.28U W=0.5U AS=0.3775P AD=0.18625P PS=2.51U
+ PD=1.245U
M$34 A10 SH1B \$52 GND nfet_03v3 L=0.28U W=0.5U AS=0.18625P AD=0.2625P
+ PS=1.245U PD=2.05U
M$35 \$54 SH2 \$52 GND nfet_03v3 L=0.28U W=0.5U AS=0.355P AD=0.18625P PS=2.42U
+ PD=1.245U
M$36 \$60 SH2B \$54 GND nfet_03v3 L=0.28U W=0.5U AS=0.18625P AD=0.2625P
+ PS=1.245U PD=2.05U
M$37 \$11 SH4 \$54 GND nfet_03v3 L=0.28U W=0.5U AS=0.3575P AD=0.18625P PS=2.43U
+ PD=1.245U
M$38 \$94 SH4B \$11 GND nfet_03v3 L=0.28U W=0.5U AS=0.18625P AD=0.27P PS=1.245U
+ PD=2.08U
M$39 OUT11 SH8 \$11 GND nfet_03v3 L=0.28U W=0.5U AS=0.3575P AD=0.18625P
+ PS=2.43U PD=1.245U
M$40 \$91 SH8B OUT11 GND nfet_03v3 L=0.28U W=0.5U AS=0.18625P AD=0.27P
+ PS=1.245U PD=2.08U
M$41 \$53 SH1 A10 GND nfet_03v3 L=0.28U W=0.5U AS=0.3775P AD=0.18625P PS=2.51U
+ PD=1.245U
M$42 A9 SH1B \$53 GND nfet_03v3 L=0.28U W=0.5U AS=0.18625P AD=0.2625P PS=1.245U
+ PD=2.05U
M$43 \$32 SH2 \$53 GND nfet_03v3 L=0.28U W=0.5U AS=0.3775P AD=0.18625P PS=2.51U
+ PD=1.245U
M$44 \$69 SH2B \$32 GND nfet_03v3 L=0.28U W=0.5U AS=0.18625P AD=0.2625P
+ PS=1.245U PD=2.05U
M$45 \$12 SH4 \$32 GND nfet_03v3 L=0.28U W=0.5U AS=0.3775P AD=0.18625P PS=2.51U
+ PD=1.245U
M$46 \$70 SH4B \$12 GND nfet_03v3 L=0.28U W=0.5U AS=0.18625P AD=0.2625P
+ PS=1.245U PD=2.05U
M$47 OUT10 SH8 \$12 GND nfet_03v3 L=0.28U W=0.5U AS=0.3775P AD=0.18625P
+ PS=2.51U PD=1.245U
M$48 \$71 SH8B OUT10 GND nfet_03v3 L=0.28U W=0.5U AS=0.18625P AD=0.2625P
+ PS=1.245U PD=2.05U
M$49 \$60 SH1 A9 GND nfet_03v3 L=0.28U W=0.5U AS=0.3775P AD=0.18625P PS=2.51U
+ PD=1.245U
M$50 A8 SH1B \$60 GND nfet_03v3 L=0.28U W=0.5U AS=0.18625P AD=0.2625P PS=1.245U
+ PD=2.05U
M$51 \$40 SH2 \$60 GND nfet_03v3 L=0.28U W=0.5U AS=0.355P AD=0.18625P PS=2.42U
+ PD=1.245U
M$52 \$92 SH2B \$40 GND nfet_03v3 L=0.28U W=0.5U AS=0.18625P AD=0.2625P
+ PS=1.245U PD=2.05U
M$53 \$13 SH4 \$40 GND nfet_03v3 L=0.28U W=0.5U AS=0.3575P AD=0.18625P PS=2.43U
+ PD=1.245U
M$54 \$78 SH4B \$13 GND nfet_03v3 L=0.28U W=0.5U AS=0.18625P AD=0.27P PS=1.245U
+ PD=2.08U
M$55 OUT9 SH8 \$13 GND nfet_03v3 L=0.28U W=0.5U AS=0.3575P AD=0.18625P PS=2.43U
+ PD=1.245U
M$56 \$79 SH8B OUT9 GND nfet_03v3 L=0.28U W=0.5U AS=0.18625P AD=0.27P PS=1.245U
+ PD=2.08U
M$57 \$69 SH1 A8 GND nfet_03v3 L=0.28U W=0.5U AS=0.3775P AD=0.18625P PS=2.51U
+ PD=1.245U
M$58 A7 SH1B \$69 GND nfet_03v3 L=0.28U W=0.5U AS=0.18625P AD=0.2625P PS=1.245U
+ PD=2.05U
M$59 \$55 SH2 \$69 GND nfet_03v3 L=0.28U W=0.5U AS=0.3775P AD=0.18625P PS=2.51U
+ PD=1.245U
M$60 \$101 SH2B \$55 GND nfet_03v3 L=0.28U W=0.5U AS=0.18625P AD=0.2625P
+ PS=1.245U PD=2.05U
M$61 \$14 SH4 \$55 GND nfet_03v3 L=0.28U W=0.5U AS=0.3775P AD=0.18625P PS=2.51U
+ PD=1.245U
M$62 \$90 SH4B \$14 GND nfet_03v3 L=0.28U W=0.5U AS=0.18625P AD=0.2625P
+ PS=1.245U PD=2.05U
M$63 OUT8 SH8 \$14 GND nfet_03v3 L=0.28U W=0.5U AS=0.3775P AD=0.18625P PS=2.51U
+ PD=1.245U
M$64 \$143 SH8B OUT8 GND nfet_03v3 L=0.28U W=0.5U AS=0.18625P AD=0.2625P
+ PS=1.245U PD=2.05U
M$65 \$92 SH1 A7 GND nfet_03v3 L=0.28U W=0.5U AS=0.3775P AD=0.18625P PS=2.51U
+ PD=1.245U
M$66 A6 SH1B \$92 GND nfet_03v3 L=0.28U W=0.5U AS=0.18625P AD=0.2625P PS=1.245U
+ PD=2.05U
M$67 \$94 SH2 \$92 GND nfet_03v3 L=0.28U W=0.5U AS=0.355P AD=0.18625P PS=2.42U
+ PD=1.245U
M$68 \$95 SH2B \$94 GND nfet_03v3 L=0.28U W=0.5U AS=0.18625P AD=0.2625P
+ PS=1.245U PD=2.05U
M$69 \$20 SH4 \$94 GND nfet_03v3 L=0.28U W=0.5U AS=0.3575P AD=0.18625P PS=2.43U
+ PD=1.245U
M$70 \$126 SH4B \$20 GND nfet_03v3 L=0.28U W=0.5U AS=0.18625P AD=0.27P
+ PS=1.245U PD=2.08U
M$71 OUT7 SH8 \$20 GND nfet_03v3 L=0.28U W=0.5U AS=0.3575P AD=0.18625P PS=2.43U
+ PD=1.245U
M$72 GND SH8B OUT7 GND nfet_03v3 L=0.28U W=0.5U AS=0.18625P AD=0.27P PS=1.245U
+ PD=2.08U
M$73 \$101 SH1 A6 GND nfet_03v3 L=0.28U W=0.5U AS=0.3775P AD=0.18625P PS=2.51U
+ PD=1.245U
M$74 A5 SH1B \$101 GND nfet_03v3 L=0.28U W=0.5U AS=0.18625P AD=0.2625P
+ PS=1.245U PD=2.05U
M$75 \$70 SH2 \$101 GND nfet_03v3 L=0.28U W=0.5U AS=0.3775P AD=0.18625P
+ PS=2.51U PD=1.245U
M$76 \$103 SH2B \$70 GND nfet_03v3 L=0.28U W=0.5U AS=0.18625P AD=0.2625P
+ PS=1.245U PD=2.05U
M$77 \$33 SH4 \$70 GND nfet_03v3 L=0.28U W=0.5U AS=0.3775P AD=0.18625P PS=2.51U
+ PD=1.245U
M$78 \$104 SH4B \$33 GND nfet_03v3 L=0.28U W=0.5U AS=0.18625P AD=0.2625P
+ PS=1.245U PD=2.05U
M$79 OUT6 SH8 \$33 GND nfet_03v3 L=0.28U W=0.5U AS=0.3775P AD=0.18625P PS=2.51U
+ PD=1.245U
M$80 GND SH8B OUT6 GND nfet_03v3 L=0.28U W=0.5U AS=0.18625P AD=0.2625P
+ PS=1.245U PD=2.05U
M$81 \$95 SH1 A5 GND nfet_03v3 L=0.28U W=0.5U AS=0.3775P AD=0.18625P PS=2.51U
+ PD=1.245U
M$82 A4 SH1B \$95 GND nfet_03v3 L=0.28U W=0.5U AS=0.18625P AD=0.2625P PS=1.245U
+ PD=2.05U
M$83 \$78 SH2 \$95 GND nfet_03v3 L=0.28U W=0.5U AS=0.355P AD=0.18625P PS=2.42U
+ PD=1.245U
M$84 \$111 SH2B \$78 GND nfet_03v3 L=0.28U W=0.5U AS=0.18625P AD=0.2625P
+ PS=1.245U PD=2.05U
M$85 \$42 SH4 \$78 GND nfet_03v3 L=0.28U W=0.5U AS=0.3575P AD=0.18625P PS=2.43U
+ PD=1.245U
M$86 \$112 SH4B \$42 GND nfet_03v3 L=0.28U W=0.5U AS=0.18625P AD=0.27P
+ PS=1.245U PD=2.08U
M$87 OUT5 SH8 \$42 GND nfet_03v3 L=0.28U W=0.5U AS=0.3575P AD=0.18625P PS=2.43U
+ PD=1.245U
M$88 GND SH8B OUT5 GND nfet_03v3 L=0.28U W=0.5U AS=0.18625P AD=0.27P PS=1.245U
+ PD=2.08U
M$89 \$103 SH1 A4 GND nfet_03v3 L=0.28U W=0.5U AS=0.3775P AD=0.18625P PS=2.51U
+ PD=1.245U
M$90 A3 SH1B \$103 GND nfet_03v3 L=0.28U W=0.5U AS=0.18625P AD=0.2625P
+ PS=1.245U PD=2.05U
M$91 \$90 SH2 \$103 GND nfet_03v3 L=0.28U W=0.5U AS=0.3775P AD=0.18625P
+ PS=2.51U PD=1.245U
M$92 \$120 SH2B \$90 GND nfet_03v3 L=0.28U W=0.5U AS=0.18625P AD=0.2625P
+ PS=1.245U PD=2.05U
M$93 \$118 SH4 \$90 GND nfet_03v3 L=0.28U W=0.5U AS=0.3775P AD=0.18625P
+ PS=2.51U PD=1.245U
M$94 \$148 SH4B \$118 GND nfet_03v3 L=0.28U W=0.5U AS=0.18625P AD=0.2625P
+ PS=1.245U PD=2.05U
M$95 OUT4 SH8 \$118 GND nfet_03v3 L=0.28U W=0.5U AS=0.3775P AD=0.18625P
+ PS=2.51U PD=1.245U
M$96 GND SH8B OUT4 GND nfet_03v3 L=0.28U W=0.5U AS=0.18625P AD=0.2625P
+ PS=1.245U PD=2.05U
M$97 \$111 SH1 A3 GND nfet_03v3 L=0.28U W=0.5U AS=0.3775P AD=0.18625P PS=2.51U
+ PD=1.245U
M$98 A2 SH1B \$111 GND nfet_03v3 L=0.28U W=0.5U AS=0.18625P AD=0.2625P
+ PS=1.245U PD=2.05U
M$99 \$126 SH2 \$111 GND nfet_03v3 L=0.28U W=0.5U AS=0.355P AD=0.18625P
+ PS=2.42U PD=1.245U
M$100 \$135 SH2B \$126 GND nfet_03v3 L=0.28U W=0.5U AS=0.18625P AD=0.2625P
+ PS=1.245U PD=2.05U
M$101 \$91 SH4 \$126 GND nfet_03v3 L=0.28U W=0.5U AS=0.3575P AD=0.18625P
+ PS=2.43U PD=1.245U
M$102 GND SH4B \$91 GND nfet_03v3 L=0.28U W=0.5U AS=0.18625P AD=0.27P PS=1.245U
+ PD=2.08U
M$103 OUT3 SH8 \$91 GND nfet_03v3 L=0.28U W=0.5U AS=0.3575P AD=0.18625P
+ PS=2.43U PD=1.245U
M$104 GND SH8B OUT3 GND nfet_03v3 L=0.28U W=0.5U AS=0.18625P AD=0.27P PS=1.245U
+ PD=2.08U
M$105 \$120 SH1 A2 GND nfet_03v3 L=0.28U W=0.5U AS=0.3775P AD=0.18625P PS=2.51U
+ PD=1.245U
M$106 A1 SH1B \$120 GND nfet_03v3 L=0.28U W=0.5U AS=0.18625P AD=0.2625P
+ PS=1.245U PD=2.05U
M$107 \$104 SH2 \$120 GND nfet_03v3 L=0.28U W=0.5U AS=0.3775P AD=0.18625P
+ PS=2.51U PD=1.245U
M$108 \$136 SH2B \$104 GND nfet_03v3 L=0.28U W=0.5U AS=0.18625P AD=0.2625P
+ PS=1.245U PD=2.05U
M$109 \$71 SH4 \$104 GND nfet_03v3 L=0.28U W=0.5U AS=0.3775P AD=0.18625P
+ PS=2.51U PD=1.245U
M$110 GND SH4B \$71 GND nfet_03v3 L=0.28U W=0.5U AS=0.18625P AD=0.2625P
+ PS=1.245U PD=2.05U
M$111 OUT2 SH8 \$71 GND nfet_03v3 L=0.28U W=0.5U AS=0.3775P AD=0.18625P
+ PS=2.51U PD=1.245U
M$112 GND SH8B OUT2 GND nfet_03v3 L=0.28U W=0.5U AS=0.18625P AD=0.2625P
+ PS=1.245U PD=2.05U
M$113 \$135 SH1 A1 GND nfet_03v3 L=0.28U W=0.5U AS=0.3775P AD=0.18625P PS=2.51U
+ PD=1.245U
M$114 A0 SH1B \$135 GND nfet_03v3 L=0.28U W=0.5U AS=0.18625P AD=0.2625P
+ PS=1.245U PD=2.05U
M$115 \$112 SH2 \$135 GND nfet_03v3 L=0.28U W=0.5U AS=0.355P AD=0.18625P
+ PS=2.42U PD=1.245U
M$116 GND SH2B \$112 GND nfet_03v3 L=0.28U W=0.5U AS=0.18625P AD=0.2625P
+ PS=1.245U PD=2.05U
M$117 \$79 SH4 \$112 GND nfet_03v3 L=0.28U W=0.5U AS=0.3575P AD=0.18625P
+ PS=2.43U PD=1.245U
M$118 GND SH4B \$79 GND nfet_03v3 L=0.28U W=0.5U AS=0.18625P AD=0.27P PS=1.245U
+ PD=2.08U
M$119 OUT1 SH8 \$79 GND nfet_03v3 L=0.28U W=0.5U AS=0.3575P AD=0.18625P
+ PS=2.43U PD=1.245U
M$120 GND SH8B OUT1 GND nfet_03v3 L=0.28U W=0.5U AS=0.18625P AD=0.27P PS=1.245U
+ PD=2.08U
M$121 \$136 SH1 A0 GND nfet_03v3 L=0.28U W=0.5U AS=0.3775P AD=0.18625P PS=2.51U
+ PD=1.245U
M$122 GND SH1B \$136 GND nfet_03v3 L=0.28U W=0.5U AS=0.18625P AD=0.2625P
+ PS=1.245U PD=2.05U
M$123 \$148 SH2 \$136 GND nfet_03v3 L=0.28U W=0.5U AS=0.3775P AD=0.18625P
+ PS=2.51U PD=1.245U
M$124 GND SH2B \$148 GND nfet_03v3 L=0.28U W=0.5U AS=0.18625P AD=0.2625P
+ PS=1.245U PD=2.05U
M$125 \$143 SH4 \$148 GND nfet_03v3 L=0.28U W=0.5U AS=0.3775P AD=0.18625P
+ PS=2.51U PD=1.245U
M$126 GND SH4B \$143 GND nfet_03v3 L=0.28U W=0.5U AS=0.18625P AD=0.2625P
+ PS=1.245U PD=2.05U
M$127 OUT0 SH8 \$143 GND nfet_03v3 L=0.28U W=0.5U AS=0.3775P AD=0.18625P
+ PS=2.51U PD=1.245U
M$128 GND SH8B OUT0 GND nfet_03v3 L=0.28U W=0.5U AS=0.18625P AD=0.2625P
+ PS=1.245U PD=2.05U
.ENDS SHIFT
