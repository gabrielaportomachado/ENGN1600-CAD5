* Extracted by KLayout with GF180MCU LVS runset on : 10/04/2026 23:34

.SUBCKT BUF VDD GND IN OUT
M$1 OUT \$7 VDD VDD pfet_03v3 L=0.28U W=1U AS=0.595P AD=0.65P PS=3.19U PD=3.3U
M$2 \$7 IN VDD VDD pfet_03v3 L=0.28U W=1U AS=0.65P AD=0.595P PS=3.3U PD=3.19U
M$3 OUT \$7 GND GND nfet_03v3 L=0.28U W=0.5U AS=0.2975P AD=0.315P PS=2.19U
+ PD=2.26U
M$4 \$7 IN GND GND nfet_03v3 L=0.28U W=0.5U AS=0.325P AD=0.2875P PS=2.3U
+ PD=2.15U
.ENDS BUF
