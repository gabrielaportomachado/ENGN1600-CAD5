* Extracted by KLayout with GF180MCU LVS runset on : 03/04/2026 23:40

.SUBCKT BUF GND VDD OUT IN
M$1 \$3 IN VDD VDD pfet_03v3 L=0.28U W=1U AS=0.65P AD=0.595P PS=3.3U PD=3.19U
M$2 OUT \$3 VDD VDD pfet_03v3 L=0.28U W=1U AS=0.595P AD=0.65P PS=3.19U PD=3.3U
M$3 \$3 IN GND GND nfet_03v3 L=0.28U W=0.5U AS=0.325P AD=0.2875P PS=2.3U
+ PD=2.15U
M$4 OUT \$3 GND GND nfet_03v3 L=0.28U W=0.5U AS=0.2975P AD=0.315P PS=2.19U
+ PD=2.26U
.ENDS BUF
