** sch_path: /foss/designs/CAD5/SHIFT.sch
.subckt SHIFT Sh1 Sh1b A0 A1 A2 A3 A4 A5 A6 A7 A8 A9 A10 A11 A12 A13 A14 A15 OUT0 OUT1 OUT2 OUT3 OUT4 OUT5 OUT6 OUT7 OUT8 OUT9
+ OUT10 OUT11 OUT12 OUT13 OUT14 OUT15 Sh2 Sh2b Sh4 Sh4b Sh8 Sh8b
*.PININFO Sh1:I Sh1b:I A0:I A1:I A2:I A3:I A4:I A5:I A6:I A7:I A8:I A9:I A10:I A11:I A12:I A13:I A14:I A15:I OUT0:O OUT1:O OUT2:O
*+ OUT3:O OUT4:O OUT5:O OUT6:O OUT7:O OUT8:O OUT9:O OUT10:O OUT11:O OUT12:O OUT13:O OUT14:O OUT15:O Sh2:I Sh2b:I Sh4:I Sh4b:I Sh8:I Sh8b:I
x1 Sh1b Sh1 A0 GND net17 1BIT
x2 Sh1b Sh1 A1 A0 net18 1BIT
x3 Sh1b Sh1 A2 A1 net19 1BIT
x4 Sh1b Sh1 A3 A2 net20 1BIT
x5 Sh1b Sh1 A4 A3 net21 1BIT
x6 Sh1b Sh1 A5 A4 net22 1BIT
x7 Sh1b Sh1 A6 A5 net23 1BIT
x8 Sh1b Sh1 A7 A6 net24 1BIT
x9 Sh1b Sh1 A8 A7 net25 1BIT
x10 Sh1b Sh1 A9 A8 net26 1BIT
x11 Sh1b Sh1 A10 A9 net27 1BIT
x12 Sh1b Sh1 A11 A10 net28 1BIT
x13 Sh1b Sh1 A12 A11 net29 1BIT
x14 Sh1b Sh1 A13 A12 net30 1BIT
x15 Sh1b Sh1 A14 A13 net31 1BIT
x16 Sh1b Sh1 A15 A14 net32 1BIT
x17 Sh2b Sh2 net17 GND net33 net34 GND net18 2BIT
x18 Sh2b Sh2 net19 net17 net35 net36 net18 net20 2BIT
x19 Sh2b Sh2 net21 net19 net37 net38 net20 net22 2BIT
x20 Sh2b Sh2 net23 net21 net39 net40 net22 net24 2BIT
x21 Sh2b Sh2 net25 net23 net41 net42 net24 net26 2BIT
x22 Sh2b Sh2 net27 net25 net43 net44 net26 net28 2BIT
x23 Sh2b Sh2 net29 net27 net45 net46 net28 net30 2BIT
x24 Sh2b Sh2 net31 net29 net47 net48 net30 net32 2BIT
x25 Sh4b Sh4 GND net33 net49 net51 net50 net52 GND net34 GND net35 GND net36 4BIT
x26 Sh4b Sh4 net33 net37 net53 net54 net55 net56 net34 net38 net35 net39 net36 net40 4BIT
x27 Sh4b Sh4 net37 net41 net57 net59 net58 net60 net38 net42 net39 net43 net40 net44 4BIT
x29 Sh4b Sh4 net41 net45 net61 net62 net63 net64 net42 net46 net43 net47 net44 net48 4BIT
x28 Sh8b Sh8 net49 GND net1 net2 net3 net4 net51 GND GND net50 GND net52 net53 GND net5 net6 net7 net8 GND net54 GND net55 GND
+ net56 8BIT
x30 Sh8b Sh8 net57 net49 net9 net10 net11 net12 net59 net51 net50 net58 net52 net60 net61 net53 net13 net14 net15 net16 net54
+ net62 net55 net63 net56 net64 8BIT
x31 OUT0 net1 BUF
x32 OUT2 net3 BUF
x33 OUT3 net4 BUF
x34 OUT1 net2 BUF
x35 OUT4 net5 BUF
x36 OUT5 net6 BUF
x37 OUT6 net7 BUF
x38 OUT7 net8 BUF
x39 OUT8 net9 BUF
x40 OUT9 net10 BUF
x41 OUT10 net11 BUF
x42 OUT11 net12 BUF
x43 OUT12 net13 BUF
x44 OUT13 net14 BUF
x45 OUT14 net15 BUF
x46 OUT15 net16 BUF
.ends

* expanding   symbol:  1BIT.sym # of pins=5
** sym_path: /foss/designs/CAD5/1BIT.sym
** sch_path: /foss/designs/CAD5/1BIT.sch
.subckt 1BIT Shb Sh Ax IN0 OUT
*.PININFO Sh:I Shb:I OUT:O Ax:I IN0:I
M2 OUT Sh IN0 GND nfet_03v3 L=0.28u W=0.5u nf=1 m=1
M1 OUT Shb Ax GND nfet_03v3 L=0.28u W=0.5u nf=1 m=1
.ends

* expanding   symbol:  2BIT.sym # of pins=8
** sym_path: /foss/designs/CAD5/2BIT.sym
** sch_path: /foss/designs/CAD5/2BIT.sch
.subckt 2BIT Shb Sh Ax IN0 OUT0 OUT1 IN1 Ax-1
*.PININFO Sh:I Shb:I OUT0:O Ax:I IN0:I Ax-1:I IN1:I OUT1:O
M2 OUT0 Sh IN0 GND nfet_03v3 L=0.28u W=0.5u nf=1 m=1
M1 OUT0 Shb Ax GND nfet_03v3 L=0.28u W=0.5u nf=1 m=1
M3 OUT1 Sh IN1 GND nfet_03v3 L=0.28u W=0.5u nf=1 m=1
M4 OUT1 Shb Ax-1 GND nfet_03v3 L=0.28u W=0.5u nf=1 m=1
.ends

* expanding   symbol:  4BIT.sym # of pins=14
** sym_path: /foss/designs/CAD5/4BIT.sym
** sch_path: /foss/designs/CAD5/4BIT.sch
.subckt 4BIT Shb Sh IN0 Ax OUT0 OUT1 OUT2 OUT3 IN1 Ax-1 IN2 Ax-2 IN3 Ax-3
*.PININFO Sh:I Shb:I OUT0:O Ax:I IN0:I Ax-1:I IN1:I OUT1:O Ax-2:I IN2:I Ax-3:I IN3:I OUT2:O OUT3:O
M2 OUT0 Sh IN0 GND nfet_03v3 L=0.28u W=0.5u nf=1 m=1
M1 OUT0 Shb Ax GND nfet_03v3 L=0.28u W=0.5u nf=1 m=1
M3 OUT1 Sh IN1 GND nfet_03v3 L=0.28u W=0.5u nf=1 m=1
M4 OUT1 Shb Ax-1 GND nfet_03v3 L=0.28u W=0.5u nf=1 m=1
M5 OUT2 Sh IN2 GND nfet_03v3 L=0.28u W=0.5u nf=1 m=1
M6 OUT2 Shb Ax-2 GND nfet_03v3 L=0.28u W=0.5u nf=1 m=1
M7 OUT3 Sh IN3 GND nfet_03v3 L=0.28u W=0.5u nf=1 m=1
M8 OUT3 Shb Ax-3 GND nfet_03v3 L=0.28u W=0.5u nf=1 m=1
.ends

* expanding   symbol:  8BIT.sym # of pins=26
** sym_path: /foss/designs/CAD5/8BIT.sym
** sch_path: /foss/designs/CAD5/8BIT.sch
.subckt 8BIT Shb Sh Ax IN0 OUT0 OUT1 OUT2 OUT3 Ax-1 IN1 IN2 Ax-2 IN3 Ax-3 Ax-4 IN4 OUT4 OUT5 OUT6 OUT7 IN5 Ax-5 IN6 Ax-6 IN7 Ax-7
*.PININFO Sh:I Shb:I OUT0:O Ax:I IN0:I Ax-1:I IN1:I OUT1:O Ax-2:I IN2:I Ax-3:I IN3:I OUT2:O OUT3:O OUT4:O Ax-4:I IN4:I Ax-5:I
*+ IN5:I OUT5:O Ax-6:I IN6:I Ax-7:I IN7:I OUT6:O OUT7:O
M2 OUT0 Sh IN0 GND nfet_03v3 L=0.28u W=0.5u nf=1 m=1
M1 OUT0 Shb Ax GND nfet_03v3 L=0.28u W=0.5u nf=1 m=1
M3 OUT1 Sh IN1 GND nfet_03v3 L=0.28u W=0.5u nf=1 m=1
M4 OUT1 Shb Ax-1 GND nfet_03v3 L=0.28u W=0.5u nf=1 m=1
M5 OUT2 Sh IN2 GND nfet_03v3 L=0.28u W=0.5u nf=1 m=1
M6 OUT2 Shb Ax-2 GND nfet_03v3 L=0.28u W=0.5u nf=1 m=1
M7 OUT3 Sh IN3 GND nfet_03v3 L=0.28u W=0.5u nf=1 m=1
M8 OUT3 Shb Ax-3 GND nfet_03v3 L=0.28u W=0.5u nf=1 m=1
M9 OUT4 Sh IN4 GND nfet_03v3 L=0.28u W=0.5u nf=1 m=1
M10 OUT4 Shb Ax-4 GND nfet_03v3 L=0.28u W=0.5u nf=1 m=1
M11 OUT5 Sh IN5 GND nfet_03v3 L=0.28u W=0.5u nf=1 m=1
M12 OUT5 Shb Ax-5 GND nfet_03v3 L=0.28u W=0.5u nf=1 m=1
M13 OUT6 Sh IN6 GND nfet_03v3 L=0.28u W=0.5u nf=1 m=1
M14 OUT6 Shb Ax-6 GND nfet_03v3 L=0.28u W=0.5u nf=1 m=1
M15 OUT7 Sh IN7 GND nfet_03v3 L=0.28u W=0.5u nf=1 m=1
M16 OUT7 Shb Ax-7 GND nfet_03v3 L=0.28u W=0.5u nf=1 m=1
.ends

* expanding   symbol:  BUF.sym # of pins=2
** sym_path: /foss/designs/CAD5/BUF.sym
** sch_path: /foss/designs/CAD5/BUF.sch
.subckt BUF OUT IN
*.PININFO IN:I OUT:O
M1 net1 IN VDD VDD pfet_03v3 L=0.28u W=1u nf=1 m=1
M2 net1 IN GND GND nfet_03v3 L=0.28u W=0.5u nf=1 m=1
M3 OUT net1 VDD VDD pfet_03v3 L=0.28u W=1u nf=1 m=1
M4 OUT net1 GND GND nfet_03v3 L=0.28u W=0.5u nf=1 m=1
.ends

.GLOBAL GND
.GLOBAL VDD
